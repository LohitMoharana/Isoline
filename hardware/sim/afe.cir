* Isoline AFE - generated by make_afe_sim.py

* behavioural single-supply op amp: Aol 120 dB, single pole set by GBW, output clamped to the rails
.subckt OPA inp inn out vcc vee params: gbw=8k
Bdiff n1 0 V = 1e6*(V(inp)-V(inn))
R1 n1 n2 1k
C1 n2 0 {1e6/(2*3.14159265*gbw*1k)}
Bout out 0 V = max(min(V(n2), V(vcc)-0.012), V(vee)+0.012)
.ends

VCC vcc 0 3.0
VREF ref 0 1.5
* electrodes: differential ECG + DC offset, common mode at mid-rail
VECG ecg 0 PWL(0.000000 -1.6500000e-04 0.002778 -1.7000000e-04 0.005556 -1.6000000e-04 0.008333 -1.4500000e-04 0.011111 -1.3000000e-04 0.013889 -1.4500000e-04 0.016667 -1.6500000e-04 0.019444 -1.7000000e-04 0.022222 -1.3500000e-04 0.025000 -1.3500000e-04 0.027778 -1.2000000e-04 0.030556 -1.2000000e-04 0.033333 -1.3000000e-04 0.036111 -1.3500000e-04 0.038889 -1.1000000e-04 0.041667 -1.2000000e-04 0.044444 -1.2000000e-04 0.047222 -1.0000000e-04 0.050000 -1.1500000e-04 0.052778 -1.1500000e-04 0.055556 -1.1000000e-04 0.058333 -8.5000000e-05 0.061111 -7.5000000e-05 0.063889 -7.5000000e-05 0.066667 -7.5000000e-05 0.069444 -8.5000000e-05 0.072222 -6.5000000e-05 0.075000 -5.5000000e-05 0.077778 -3.5000000e-05 0.080556 -4.0000000e-05 0.083333 -3.5000000e-05 0.086111 -4.0000000e-05 0.088889 -2.5000000e-05 0.091667 -5.0000000e-06 0.094444 1.0000000e-05 0.097222 1.5000000e-05 0.100000 2.0000000e-05 0.102778 2.0000000e-05 0.105556 3.0000000e-05 0.108333 5.0000000e-05 0.111111 6.0000000e-05 0.113889 7.0000000e-05 0.116667 6.5000000e-05 0.119444 6.0000000e-05 0.122222 6.5000000e-05 0.125000 8.5000000e-05 0.127778 1.0500000e-04 0.130556 1.0500000e-04 0.133333 9.5000000e-05 0.136111 1.0000000e-04 0.138889 1.0000000e-04 0.141667 1.1500000e-04 0.144444 1.1500000e-04 0.147222 1.2000000e-04 0.150000 1.1000000e-04 0.152778 1.0000000e-04 0.155556 1.1000000e-04 0.158333 1.0000000e-04 0.161111 9.5000000e-05 0.163889 8.0000000e-05 0.166667 7.5000000e-05 0.169444 5.5000000e-05 0.172222 4.5000000e-05 0.175000 4.5000000e-05 0.177778 3.5000000e-05 0.180556 2.0000000e-05 0.183333 1.5000000e-05 0.186111 -1.5000000e-05 0.188889 -1.5000000e-05 0.191667 -1.5000000e-05 0.194444 -1.5000000e-05 0.197222 -3.0000000e-05 0.200000 -4.5000000e-05 0.202778 -5.0000000e-05 0.205556 -6.0000000e-05 0.208333 -4.5000000e-05 0.211111 -5.0000000e-05 0.213889 -5.5000000e-05 0.216667 -8.0000000e-05 0.219444 -8.5000000e-05 0.222222 -8.5000000e-05 0.225000 -8.5000000e-05 0.227778 -7.5000000e-05 0.230556 -7.0000000e-05 0.233333 -7.0000000e-05 0.236111 -8.5000000e-05 0.238889 -7.5000000e-05 0.241667 -8.0000000e-05 0.244444 -6.0000000e-05 0.247222 -6.5000000e-05 0.250000 -7.5000000e-05 0.252778 -9.0000000e-05 0.255556 -9.0000000e-05 0.258333 -7.0000000e-05 0.261111 -4.5000000e-05 0.263889 -6.0000000e-05 0.266667 -7.5000000e-05 0.269444 -8.0000000e-05 0.272222 -7.5000000e-05 0.275000 -6.0000000e-05 0.277778 -5.0000000e-05 0.280556 -6.5000000e-05 0.283333 -7.0000000e-05 0.286111 -9.0000000e-05 0.288889 -8.5000000e-05 0.291667 -6.5000000e-05 0.294444 -5.5000000e-05 0.297222 -5.5000000e-05 0.300000 -6.5000000e-05 0.302778 -9.5000000e-05 0.305556 -7.5000000e-05 0.308333 -7.0000000e-05 0.311111 -6.0000000e-05 0.313889 -5.0000000e-05 0.316667 -4.5000000e-05 0.319444 -7.0000000e-05 0.322222 -5.5000000e-05 0.325000 -5.5000000e-05 0.327778 -5.0000000e-05 0.330556 -5.5000000e-05 0.333333 -6.0000000e-05 0.336111 -6.0000000e-05 0.338889 -5.5000000e-05 0.341667 -4.5000000e-05 0.344444 -4.5000000e-05 0.347222 -5.0000000e-05 0.350000 -6.0000000e-05 0.352778 -5.5000000e-05 0.355556 -6.5000000e-05 0.358333 -5.0000000e-05 0.361111 -4.5000000e-05 0.363889 -5.0000000e-05 0.366667 -6.0000000e-05 0.369444 -8.0000000e-05 0.372222 -7.5000000e-05 0.375000 -6.5000000e-05 0.377778 -5.5000000e-05 0.380556 -6.0000000e-05 0.383333 -7.5000000e-05 0.386111 -8.0000000e-05 0.388889 -7.0000000e-05 0.391667 -5.5000000e-05 0.394444 -5.0000000e-05 0.397222 -6.5000000e-05 0.400000 -5.5000000e-05 0.402778 -6.5000000e-05 0.405556 -6.0000000e-05 0.408333 -5.0000000e-05 0.411111 -4.5000000e-05 0.413889 -5.5000000e-05 0.416667 -7.5000000e-05 0.419444 -8.0000000e-05 0.422222 -8.0000000e-05 0.425000 -8.0000000e-05 0.427778 -6.5000000e-05 0.430556 -6.0000000e-05 0.433333 -5.0000000e-05 0.436111 -6.5000000e-05 0.438889 -7.0000000e-05 0.441667 -6.0000000e-05 0.444444 -6.0000000e-05 0.447222 -6.5000000e-05 0.450000 -7.5000000e-05 0.452778 -9.0000000e-05 0.455556 -7.5000000e-05 0.458333 -7.5000000e-05 0.461111 -6.5000000e-05 0.463889 -8.5000000e-05 0.466667 -8.5000000e-05 0.469444 -9.0000000e-05 0.472222 -8.0000000e-05 0.475000 -6.5000000e-05 0.477778 -6.0000000e-05 0.480556 -5.5000000e-05 0.483333 -6.5000000e-05 0.486111 -8.0000000e-05 0.488889 -7.5000000e-05 0.491667 -7.5000000e-05 0.494444 -7.0000000e-05 0.497222 -7.0000000e-05 0.500000 -7.5000000e-05 0.502778 -8.5000000e-05 0.505556 -8.5000000e-05 0.508333 -7.0000000e-05 0.511111 -5.5000000e-05 0.513889 -5.5000000e-05 0.516667 -7.5000000e-05 0.519444 -8.5000000e-05 0.522222 -8.0000000e-05 0.525000 -7.5000000e-05 0.527778 -7.0000000e-05 0.530556 -7.5000000e-05 0.533333 -8.5000000e-05 0.536111 -9.5000000e-05 0.538889 -9.0000000e-05 0.541667 -8.0000000e-05 0.544444 -6.5000000e-05 0.547222 -6.0000000e-05 0.550000 -6.0000000e-05 0.552778 -6.5000000e-05 0.555556 -6.5000000e-05 0.558333 -5.0000000e-05 0.561111 -3.0000000e-05 0.563889 -1.5000000e-05 0.566667 -5.0000000e-06 0.569444 1.0000000e-05 0.572222 3.0000000e-05 0.575000 5.0000000e-05 0.577778 9.0000000e-05 0.580556 1.0000000e-04 0.583333 1.2000000e-04 0.586111 1.1000000e-04 0.588889 1.1000000e-04 0.591667 9.5000000e-05 0.594444 1.0500000e-04 0.597222 1.0000000e-04 0.600000 8.0000000e-05 0.602778 6.5000000e-05 0.605556 6.5000000e-05 0.608333 6.5000000e-05 0.611111 7.0000000e-05 0.613889 5.5000000e-05 0.616667 3.5000000e-05 0.619444 3.5000000e-05 0.622222 3.0000000e-05 0.625000 2.0000000e-05 0.627778 1.5000000e-05 0.630556 0.0000000e+00 0.633333 -2.5000000e-05 0.636111 -4.5000000e-05 0.638889 -6.5000000e-05 0.641667 -6.0000000e-05 0.644444 -7.0000000e-05 0.647222 -7.0000000e-05 0.650000 -8.0000000e-05 0.652778 -8.0000000e-05 0.655556 -8.5000000e-05 0.658333 -6.5000000e-05 0.661111 -6.0000000e-05 0.663889 -6.5000000e-05 0.666667 -8.0000000e-05 0.669444 -1.0000000e-04 0.672222 -8.0000000e-05 0.675000 -8.5000000e-05 0.677778 -8.0000000e-05 0.680556 -8.0000000e-05 0.683333 -9.5000000e-05 0.686111 -1.0000000e-04 0.688889 -1.0500000e-04 0.691667 -1.0500000e-04 0.694444 -1.0500000e-04 0.697222 -1.1500000e-04 0.700000 -1.4500000e-04 0.702778 -1.6500000e-04 0.705556 -1.8500000e-04 0.708333 -1.7000000e-04 0.711111 -6.5000000e-05 0.713889 1.0500000e-04 0.716667 3.1500000e-04 0.719444 5.5500000e-04 0.722222 8.7000000e-04 0.725000 1.1600000e-03 0.727778 1.2700000e-03 0.730556 1.1600000e-03 0.733333 8.8500000e-04 0.736111 6.2000000e-04 0.738889 3.9500000e-04 0.741667 2.3500000e-04 0.744444 1.8000000e-04 0.747222 1.7500000e-04 0.750000 1.3000000e-04 0.752778 7.5000000e-05 0.755556 5.0000000e-05 0.758333 3.0000000e-05 0.761111 1.5000000e-05 0.763889 -5.0000000e-06 0.766667 -4.5000000e-05 0.769444 -1.0500000e-04 0.772222 -1.4000000e-04 0.775000 -1.4500000e-04 0.777778 -1.3000000e-04 0.780556 -1.5500000e-04 0.783333 -1.7000000e-04 0.786111 -2.0000000e-04 0.788889 -2.0000000e-04 0.791667 -2.0000000e-04 0.794444 -1.9000000e-04 0.797222 -1.9000000e-04 0.800000 -2.0000000e-04 0.802778 -2.0500000e-04 0.805556 -2.1500000e-04 0.808333 -2.0500000e-04 0.811111 -2.0000000e-04 0.813889 -2.0500000e-04 0.816667 -2.1000000e-04 0.819444 -2.1500000e-04 0.822222 -2.0500000e-04 0.825000 -1.9500000e-04 0.827778 -1.9000000e-04 0.830556 -2.0500000e-04 0.833333 -2.0500000e-04 0.836111 -2.1000000e-04 0.838889 -1.9000000e-04 0.841667 -1.8000000e-04 0.844444 -1.6000000e-04 0.847222 -1.7000000e-04 0.850000 -1.9500000e-04 0.852778 -1.9500000e-04 0.855556 -1.8000000e-04 0.858333 -1.7000000e-04 0.861111 -1.6000000e-04 0.863889 -1.5500000e-04 0.866667 -1.7000000e-04 0.869444 -1.8500000e-04 0.872222 -1.8500000e-04 0.875000 -1.7000000e-04 0.877778 -1.6000000e-04 0.880556 -1.6500000e-04 0.883333 -1.7500000e-04 0.886111 -1.8500000e-04 0.888889 -1.8000000e-04 0.891667 -1.8000000e-04 0.894444 -1.6000000e-04 0.897222 -1.5500000e-04 0.900000 -1.6500000e-04 0.902778 -1.6000000e-04 0.905556 -1.7000000e-04 0.908333 -1.4500000e-04 0.911111 -1.3500000e-04 0.913889 -1.4500000e-04 0.916667 -1.6000000e-04 0.919444 -1.5500000e-04 0.922222 -1.5500000e-04 0.925000 -1.2500000e-04 0.927778 -1.2000000e-04 0.930556 -1.1500000e-04 0.933333 -1.3000000e-04 0.936111 -1.3000000e-04 0.938889 -1.1000000e-04 0.941667 -9.5000000e-05 0.944444 -9.0000000e-05 0.947222 -1.0000000e-04 0.950000 -1.1000000e-04 0.952778 -1.0500000e-04 0.955556 -8.5000000e-05 0.958333 -8.0000000e-05 0.961111 -6.5000000e-05 0.963889 -5.5000000e-05 0.966667 -4.5000000e-05 0.969444 -5.5000000e-05 0.972222 -5.5000000e-05 0.975000 -5.0000000e-05 0.977778 -2.0000000e-05 0.980556 -5.0000000e-06 0.983333 0.0000000e+00 0.986111 -1.0000000e-05 0.988889 1.0000000e-05 0.991667 1.5000000e-05 0.994444 3.0000000e-05 0.997222 3.5000000e-05 1.000000 3.5000000e-05 1.002778 4.0000000e-05 1.005556 5.0000000e-05 1.008333 6.5000000e-05 1.011111 9.0000000e-05 1.013889 1.0000000e-04 1.016667 1.0500000e-04 1.019444 9.5000000e-05 1.022222 9.5000000e-05 1.025000 1.1000000e-04 1.027778 1.1500000e-04 1.030556 1.2500000e-04 1.033333 1.2000000e-04 1.036111 1.2000000e-04 1.038889 1.1500000e-04 1.041667 1.0000000e-04 1.044444 1.2000000e-04 1.047222 1.2500000e-04 1.050000 1.0500000e-04 1.052778 7.5000000e-05 1.055556 7.5000000e-05 1.058333 7.0000000e-05 1.061111 9.0000000e-05 1.063889 7.0000000e-05 1.066667 6.0000000e-05 1.069444 5.0000000e-05 1.072222 3.5000000e-05 1.075000 3.5000000e-05 1.077778 4.5000000e-05 1.080556 2.0000000e-05 1.083333 0.0000000e+00 1.086111 -3.5000000e-05 1.088889 -3.0000000e-05 1.091667 -2.0000000e-05 1.094444 -2.5000000e-05 1.097222 -3.0000000e-05 1.100000 -3.5000000e-05 1.102778 -6.5000000e-05 1.105556 -6.0000000e-05 1.108333 -5.5000000e-05 1.111111 -5.5000000e-05 1.113889 -5.5000000e-05 1.116667 -7.0000000e-05 1.119444 -8.0000000e-05 1.122222 -6.5000000e-05 1.125000 -6.5000000e-05 1.127778 -6.0000000e-05 1.130556 -5.5000000e-05 1.133333 -8.5000000e-05 1.136111 -9.0000000e-05 1.138889 -8.5000000e-05 1.141667 -7.0000000e-05 1.144444 -6.5000000e-05 1.147222 -6.5000000e-05 1.150000 -7.0000000e-05 1.152778 -8.0000000e-05 1.155556 -8.5000000e-05 1.158333 -7.5000000e-05 1.161111 -5.0000000e-05 1.163889 -5.0000000e-05 1.166667 -5.5000000e-05 1.169444 -7.0000000e-05 1.172222 -7.5000000e-05 1.175000 -7.0000000e-05 1.177778 -6.0000000e-05 1.180556 -6.0000000e-05 1.183333 -5.5000000e-05 1.186111 -7.5000000e-05 1.188889 -6.0000000e-05 1.191667 -5.5000000e-05 1.194444 -5.5000000e-05 1.197222 -5.5000000e-05 1.200000 -6.5000000e-05 1.202778 -7.0000000e-05 1.205556 -5.5000000e-05 1.208333 -5.0000000e-05 1.211111 -3.5000000e-05 1.213889 -4.0000000e-05 1.216667 -4.0000000e-05 1.219444 -5.0000000e-05 1.222222 -5.0000000e-05 1.225000 -3.0000000e-05 1.227778 -1.5000000e-05 1.230556 -3.0000000e-05 1.233333 -3.5000000e-05 1.236111 -4.0000000e-05 1.238889 -3.5000000e-05 1.241667 -3.5000000e-05 1.244444 -2.5000000e-05 1.247222 -2.0000000e-05 1.250000 -3.5000000e-05 1.252778 -4.5000000e-05 1.255556 -5.0000000e-05 1.258333 -3.5000000e-05 1.261111 -3.5000000e-05 1.263889 -3.5000000e-05 1.266667 -5.5000000e-05 1.269444 -6.5000000e-05 1.272222 -5.5000000e-05 1.275000 -4.5000000e-05 1.277778 -4.5000000e-05 1.280556 -4.0000000e-05 1.283333 -5.5000000e-05 1.286111 -5.0000000e-05 1.288889 -5.0000000e-05 1.291667 -5.0000000e-05 1.294444 -4.5000000e-05 1.297222 -3.0000000e-05 1.300000 -4.5000000e-05 1.302778 -5.5000000e-05 1.305556 -5.5000000e-05 1.308333 -5.0000000e-05 1.311111 -4.0000000e-05 1.313889 -5.0000000e-05 1.316667 -5.5000000e-05 1.319444 -4.5000000e-05 1.322222 -4.0000000e-05 1.325000 -3.5000000e-05 1.327778 -4.0000000e-05 1.330556 -3.5000000e-05 1.333333 -4.5000000e-05 1.336111 -4.5000000e-05 1.338889 -5.0000000e-05 1.341667 -3.5000000e-05 1.344444 -4.0000000e-05 1.347222 -4.0000000e-05 1.350000 -4.0000000e-05 1.352778 -5.0000000e-05 1.355556 -4.0000000e-05 1.358333 -4.0000000e-05 1.361111 -4.0000000e-05 1.363889 -5.0000000e-05 1.366667 -5.5000000e-05 1.369444 -5.5000000e-05 1.372222 -6.0000000e-05 1.375000 -3.5000000e-05 1.377778 -4.5000000e-05 1.380556 -4.0000000e-05 1.383333 -4.0000000e-05 1.386111 -4.0000000e-05 1.388889 -5.0000000e-05 1.391667 -5.5000000e-05 1.394444 -5.0000000e-05 1.397222 -3.5000000e-05 1.400000 -4.5000000e-05 1.402778 -5.5000000e-05 1.405556 -6.5000000e-05 1.408333 -5.5000000e-05 1.411111 -5.5000000e-05 1.413889 -4.5000000e-05 1.416667 -5.5000000e-05 1.419444 -6.0000000e-05 1.422222 -5.0000000e-05 1.425000 -4.5000000e-05 1.427778 -4.0000000e-05 1.430556 -3.5000000e-05 1.433333 -4.0000000e-05 1.436111 -5.0000000e-05 1.438889 -4.5000000e-05 1.441667 -4.0000000e-05 1.444444 -2.5000000e-05 1.447222 -2.5000000e-05 1.450000 -2.5000000e-05 1.452778 -3.5000000e-05 1.455556 -2.5000000e-05 1.458333 -1.0000000e-05 1.461111 -1.0000000e-05 1.463889 -5.0000000e-06 1.466667 1.0000000e-05 1.469444 2.5000000e-05 1.472222 7.5000000e-05 1.475000 1.2000000e-04 1.477778 1.3500000e-04 1.480556 1.4500000e-04 1.483333 1.3000000e-04 1.486111 1.0500000e-04 1.488889 1.1000000e-04 1.491667 1.2500000e-04 1.494444 1.1500000e-04 1.497222 9.0000000e-05 1.500000 7.5000000e-05 1.502778 7.5000000e-05 1.505556 7.0000000e-05 1.508333 7.5000000e-05 1.511111 8.0000000e-05 1.513889 7.0000000e-05 1.516667 5.0000000e-05 1.519444 2.5000000e-05 1.522222 0.0000000e+00 1.525000 -1.0000000e-05 1.527778 -1.5000000e-05 1.530556 -1.5000000e-05 1.533333 -2.5000000e-05 1.536111 -4.5000000e-05 1.538889 -4.5000000e-05 1.541667 -3.0000000e-05 1.544444 -3.5000000e-05 1.547222 -4.0000000e-05 1.550000 -5.0000000e-05 1.552778 -6.0000000e-05 1.555556 -6.5000000e-05 1.558333 -6.0000000e-05 1.561111 -6.5000000e-05 1.563889 -5.5000000e-05 1.566667 -6.5000000e-05 1.569444 -7.0000000e-05 1.572222 -7.5000000e-05 1.575000 -7.0000000e-05 1.577778 -6.0000000e-05 1.580556 -6.0000000e-05 1.583333 -7.5000000e-05 1.586111 -9.5000000e-05 1.588889 -7.0000000e-05 1.591667 -7.0000000e-05 1.594444 -8.5000000e-05 1.597222 -1.0500000e-04 1.600000 -1.4000000e-04 1.602778 -1.5500000e-04 1.605556 -1.2500000e-04 1.608333 -3.0000000e-05 1.611111 1.2500000e-04 1.613889 3.1000000e-04 1.616667 5.3000000e-04 1.619444 8.1500000e-04 1.622222 1.1250000e-03 1.625000 1.3100000e-03 1.627778 1.2200000e-03 1.630556 9.3500000e-04 1.633333 6.5000000e-04 1.636111 4.1500000e-04 1.638889 2.8000000e-04 1.641667 2.3000000e-04 1.644444 2.3000000e-04 1.647222 1.9500000e-04 1.650000 1.5500000e-04 1.652778 1.3000000e-04 1.655556 9.0000000e-05 1.658333 6.0000000e-05 1.661111 2.5000000e-05 1.663889 -4.5000000e-05 1.666667 -8.5000000e-05 1.669444 -1.0500000e-04 1.672222 -1.1500000e-04 1.675000 -1.3000000e-04 1.677778 -1.3500000e-04 1.680556 -1.4000000e-04 1.683333 -1.4500000e-04 1.686111 -1.6000000e-04 1.688889 -1.7500000e-04 1.691667 -1.7500000e-04 1.694444 -1.6500000e-04 1.697222 -1.6500000e-04 1.700000 -1.7500000e-04 1.702778 -1.8000000e-04 1.705556 -1.8500000e-04 1.708333 -1.7500000e-04 1.711111 -1.7000000e-04 1.713889 -1.6000000e-04 1.716667 -1.6500000e-04 1.719444 -1.7500000e-04 1.722222 -1.9000000e-04 1.725000 -1.7500000e-04 1.727778 -1.7500000e-04 1.730556 -1.7000000e-04 1.733333 -1.8000000e-04 1.736111 -1.8500000e-04 1.738889 -1.8500000e-04 1.741667 -1.7000000e-04 1.744444 -1.8000000e-04 1.747222 -1.8500000e-04 1.750000 -1.7500000e-04 1.752778 -1.8000000e-04 1.755556 -1.8000000e-04 1.758333 -1.7000000e-04 1.761111 -1.6000000e-04 1.763889 -1.5500000e-04 1.766667 -1.6500000e-04 1.769444 -1.7500000e-04 1.772222 -1.7000000e-04 1.775000 -1.7000000e-04 1.777778 -1.7000000e-04 1.780556 -1.7000000e-04 1.783333 -1.8500000e-04 1.786111 -1.8000000e-04 1.788889 -1.8000000e-04 1.791667 -1.7500000e-04 1.794444 -1.6500000e-04 1.797222 -1.5500000e-04 1.800000 -1.5500000e-04 1.802778 -1.7500000e-04 1.805556 -1.7000000e-04 1.808333 -1.5000000e-04 1.811111 -1.4500000e-04 1.813889 -1.3500000e-04 1.816667 -1.5500000e-04 1.819444 -1.5000000e-04 1.822222 -1.4500000e-04 1.825000 -1.3000000e-04 1.827778 -1.1500000e-04 1.830556 -1.1000000e-04 1.833333 -1.2000000e-04 1.836111 -1.3500000e-04 1.838889 -1.2000000e-04 1.841667 -1.0500000e-04 1.844444 -9.5000000e-05 1.847222 -1.0000000e-04 1.850000 -1.1000000e-04 1.852778 -9.0000000e-05 1.855556 -7.5000000e-05 1.858333 -6.5000000e-05 1.861111 -4.0000000e-05 1.863889 -5.0000000e-05 1.866667 -4.5000000e-05 1.869444 -5.5000000e-05 1.872222 -3.0000000e-05 1.875000 -2.5000000e-05 1.877778 0.0000000e+00 1.880556 1.0000000e-05 1.883333 2.0000000e-05 1.886111 1.5000000e-05 1.888889 1.5000000e-05 1.891667 4.0000000e-05 1.894444 5.0000000e-05 1.897222 6.0000000e-05 1.900000 5.5000000e-05 1.902778 6.0000000e-05 1.905556 6.0000000e-05 1.908333 7.5000000e-05 1.911111 9.5000000e-05 1.913889 1.0500000e-04 1.916667 1.0500000e-04 1.919444 1.0500000e-04 1.922222 1.0000000e-04 1.925000 1.1000000e-04 1.927778 1.2000000e-04 1.930556 1.2500000e-04 1.933333 1.0500000e-04 1.936111 1.0500000e-04 1.938889 1.0500000e-04 1.941667 9.5000000e-05 1.944444 1.0000000e-04 1.947222 8.5000000e-05 1.950000 7.5000000e-05 1.952778 7.0000000e-05 1.955556 6.0000000e-05 1.958333 4.5000000e-05 1.961111 4.0000000e-05 1.963889 4.0000000e-05 1.966667 2.0000000e-05 1.969444 1.0000000e-05 1.972222 0.0000000e+00 1.975000 5.0000000e-06 1.977778 -1.0000000e-05 1.980556 -2.0000000e-05 1.983333 -3.0000000e-05 1.986111 -4.5000000e-05 1.988889 -3.0000000e-05 1.991667 -6.5000000e-05 1.994444 -4.0000000e-05 1.997222 -5.0000000e-05 2.000000 -6.0000000e-05 2.002778 -5.5000000e-05 2.005556 -7.0000000e-05 2.008333 -6.0000000e-05 2.011111 -7.0000000e-05 2.013889 -7.0000000e-05 2.016667 -7.0000000e-05 2.019444 -8.0000000e-05 2.022222 -7.5000000e-05 2.025000 -8.0000000e-05 2.027778 -6.5000000e-05 2.030556 -7.5000000e-05 2.033333 -7.0000000e-05 2.036111 -8.0000000e-05 2.038889 -7.5000000e-05 2.041667 -6.5000000e-05 2.044444 -5.0000000e-05 2.047222 -6.0000000e-05 2.050000 -7.5000000e-05 2.052778 -8.0000000e-05 2.055556 -7.5000000e-05 2.058333 -5.5000000e-05 2.061111 -5.5000000e-05 2.063889 -5.5000000e-05 2.066667 -6.5000000e-05 2.069444 -7.5000000e-05 2.072222 -6.5000000e-05 2.075000 -6.0000000e-05 2.077778 -5.0000000e-05 2.080556 -6.5000000e-05 2.083333 -7.5000000e-05 2.086111 -7.5000000e-05 2.088889 -7.0000000e-05 2.091667 -6.5000000e-05 2.094444 -3.5000000e-05 2.097222 -4.0000000e-05 2.100000 -4.0000000e-05 2.102778 -6.0000000e-05 2.105556 -7.0000000e-05 2.108333 -6.0000000e-05 2.111111 -4.5000000e-05 2.113889 -4.5000000e-05 2.116667 -5.5000000e-05 2.119444 -6.5000000e-05 2.122222 -7.0000000e-05 2.125000 -5.5000000e-05 2.127778 -4.0000000e-05 2.130556 -4.0000000e-05 2.133333 -5.5000000e-05 2.136111 -5.5000000e-05 2.138889 -5.0000000e-05 2.141667 -5.0000000e-05 2.144444 -5.0000000e-05 2.147222 -7.0000000e-05 2.150000 -6.5000000e-05 2.152778 -6.5000000e-05 2.155556 -6.0000000e-05 2.158333 -4.5000000e-05 2.161111 -3.5000000e-05 2.163889 -4.0000000e-05 2.166667 -5.5000000e-05 2.169444 -5.5000000e-05 2.172222 -5.5000000e-05 2.175000 -5.0000000e-05 2.177778 -4.0000000e-05 2.180556 -5.0000000e-05 2.183333 -5.0000000e-05 2.186111 -6.0000000e-05 2.188889 -6.0000000e-05 2.191667 -5.0000000e-05 2.194444 -2.5000000e-05 2.197222 -5.0000000e-05 2.200000 -4.5000000e-05 2.202778 -5.5000000e-05 2.205556 -4.5000000e-05 2.208333 -4.5000000e-05 2.211111 -4.0000000e-05 2.213889 -5.0000000e-05 2.216667 -5.0000000e-05 2.219444 -5.0000000e-05 2.222222 -5.0000000e-05 2.225000 -5.0000000e-05 2.227778 -3.5000000e-05 2.230556 -3.0000000e-05 2.233333 -4.5000000e-05 2.236111 -6.0000000e-05 2.238889 -5.0000000e-05 2.241667 -3.5000000e-05 2.244444 -2.5000000e-05 2.247222 -4.0000000e-05 2.250000 -4.5000000e-05 2.252778 -6.0000000e-05 2.255556 -6.5000000e-05 2.258333 -5.5000000e-05 2.261111 -4.0000000e-05 2.263889 -4.0000000e-05 2.266667 -4.0000000e-05 2.269444 -5.0000000e-05 2.272222 -5.5000000e-05 2.275000 -5.0000000e-05 2.277778 -3.5000000e-05 2.280556 -3.5000000e-05 2.283333 -3.5000000e-05 2.286111 -5.5000000e-05 2.288889 -6.0000000e-05 2.291667 -4.0000000e-05 2.294444 -3.0000000e-05 2.297222 -4.0000000e-05 2.300000 -5.0000000e-05 2.302778 -5.5000000e-05 2.305556 -6.5000000e-05 2.308333 -4.5000000e-05 2.311111 -3.0000000e-05 2.313889 -3.0000000e-05 2.316667 -3.0000000e-05 2.319444 -4.5000000e-05 2.322222 -6.0000000e-05 2.325000 -4.5000000e-05 2.327778 -3.5000000e-05 2.330556 -2.0000000e-05 2.333333 -2.5000000e-05 2.336111 -2.5000000e-05 2.338889 -3.0000000e-05 2.341667 -1.5000000e-05 2.344444 -5.0000000e-06 2.347222 5.0000000e-06 2.350000 -5.0000000e-06 2.352778 -1.5000000e-05 2.355556 0.0000000e+00 2.358333 3.0000000e-05 2.361111 8.0000000e-05 2.363889 1.1500000e-04 2.366667 1.3500000e-04 2.369444 1.2500000e-04 2.372222 1.1000000e-04 2.375000 9.5000000e-05 2.377778 1.2500000e-04 2.380556 1.0500000e-04 2.383333 8.0000000e-05 2.386111 7.0000000e-05 2.388889 6.0000000e-05 2.391667 7.5000000e-05 2.394444 8.0000000e-05 2.397222 5.5000000e-05 2.400000 3.0000000e-05 2.402778 2.0000000e-05 2.405556 1.0000000e-05 2.408333 2.0000000e-05 2.411111 1.5000000e-05 2.413889 -3.0000000e-05 2.416667 -5.0000000e-05 2.419444 -6.5000000e-05 2.422222 -6.5000000e-05 2.425000 -6.5000000e-05 2.427778 -6.5000000e-05 2.430556 -8.0000000e-05 2.433333 -9.0000000e-05 2.436111 -8.5000000e-05 2.438889 -8.5000000e-05 2.441667 -8.5000000e-05 2.444444 -7.5000000e-05 2.447222 -9.0000000e-05 2.450000 -1.0500000e-04 2.452778 -1.0500000e-04 2.455556 -1.2500000e-04 2.458333 -1.1000000e-04 2.461111 -1.0000000e-04 2.463889 -1.3000000e-04 2.466667 -1.2500000e-04 2.469444 -1.2000000e-04 2.472222 -1.2000000e-04 2.475000 -1.1000000e-04 2.477778 -1.0500000e-04 2.480556 -1.1500000e-04 2.483333 -1.3000000e-04 2.486111 -1.5000000e-04 2.488889 -1.8000000e-04 2.491667 -1.8500000e-04 2.494444 -1.6500000e-04 2.497222 -1.0500000e-04 2.500000 3.5000000e-05 2.502778 2.4000000e-04 2.505556 4.8000000e-04 2.508333 8.0000000e-04 2.511111 1.1000000e-03 2.513889 1.2200000e-03 2.516667 1.0950000e-03 2.519444 7.8000000e-04 2.522222 5.1000000e-04 2.525000 2.7500000e-04 2.527778 1.4500000e-04 2.530556 8.0000000e-05 2.533333 4.5000000e-05 2.536111 -5.0000000e-06 2.538889 0.0000000e+00 2.541667 5.0000000e-06 2.544444 -1.0000000e-05 2.547222 -6.0000000e-05 2.550000 -9.0000000e-05 2.552778 -1.4000000e-04 2.555556 -1.7000000e-04 2.558333 -1.8500000e-04 2.561111 -1.8000000e-04 2.563889 -1.8000000e-04 2.566667 -1.8000000e-04 2.569444 -1.9000000e-04 2.572222 -1.9500000e-04 2.575000 -2.0000000e-04 2.577778 -2.0000000e-04 2.580556 -2.1000000e-04 2.583333 -2.2500000e-04 2.586111 -2.2500000e-04 2.588889 -2.2000000e-04 2.591667 -2.1500000e-04 2.594444 -2.0500000e-04 2.597222 -1.9500000e-04 2.600000 -2.0000000e-04 2.602778 -2.1500000e-04 2.605556 -2.2500000e-04 2.608333 -2.1500000e-04 2.611111 -2.0000000e-04 2.613889 -2.1000000e-04 2.616667 -2.1500000e-04 2.619444 -2.2000000e-04 2.622222 -2.1500000e-04 2.625000 -2.0000000e-04 2.627778 -1.9500000e-04 2.630556 -2.2000000e-04 2.633333 -2.1000000e-04 2.636111 -2.2500000e-04 2.638889 -2.2500000e-04 2.641667 -2.1000000e-04 2.644444 -1.8500000e-04 2.647222 -2.0000000e-04 2.650000 -2.3000000e-04 2.652778 -2.3500000e-04 2.655556 -2.1000000e-04 2.658333 -1.9000000e-04 2.661111 -1.8500000e-04 2.663889 -2.0000000e-04 2.666667 -2.0500000e-04 2.669444 -2.0000000e-04 2.672222 -1.9000000e-04 2.675000 -1.9000000e-04 2.677778 -1.9500000e-04 2.680556 -1.9000000e-04 2.683333 -2.0000000e-04 2.686111 -2.0000000e-04 2.688889 -1.9500000e-04 2.691667 -1.8500000e-04 2.694444 -1.7000000e-04 2.697222 -1.6500000e-04 2.700000 -1.7500000e-04 2.702778 -1.8000000e-04 2.705556 -1.8500000e-04 2.708333 -1.7000000e-04 2.711111 -1.6000000e-04 2.713889 -1.6500000e-04 2.716667 -1.7500000e-04 2.719444 -1.6000000e-04 2.722222 -1.6000000e-04 2.725000 -1.5000000e-04 2.727778 -1.3500000e-04 2.730556 -1.2000000e-04 2.733333 -1.3000000e-04 2.736111 -1.3500000e-04 2.738889 -1.3500000e-04 2.741667 -1.1500000e-04 2.744444 -8.5000000e-05 2.747222 -9.0000000e-05 2.750000 -9.0000000e-05 2.752778 -8.5000000e-05 2.755556 -7.5000000e-05 2.758333 -6.5000000e-05 2.761111 -4.5000000e-05 2.763889 -5.0000000e-05 2.766667 -4.5000000e-05 2.769444 -4.0000000e-05 2.772222 -3.5000000e-05 2.775000 -1.5000000e-05 2.777778 5.0000000e-06 2.780556 5.0000000e-06 2.783333 0.0000000e+00 2.786111 0.0000000e+00 2.788889 0.0000000e+00 2.791667 3.5000000e-05 2.794444 5.5000000e-05 2.797222 5.5000000e-05 2.800000 4.5000000e-05 2.802778 5.0000000e-05 2.805556 6.0000000e-05 2.808333 7.0000000e-05 2.811111 8.5000000e-05 2.813889 6.5000000e-05 2.816667 6.5000000e-05 2.819444 6.0000000e-05 2.822222 5.5000000e-05 2.825000 5.0000000e-05 2.827778 6.5000000e-05 2.830556 4.0000000e-05 2.833333 5.5000000e-05 2.836111 4.5000000e-05 2.838889 2.0000000e-05 2.841667 1.0000000e-05 2.844444 1.0000000e-05 2.847222 1.0000000e-05 2.850000 5.0000000e-06 2.852778 -1.5000000e-05 2.855556 -3.0000000e-05 2.858333 -4.0000000e-05 2.861111 -3.0000000e-05 2.863889 -4.5000000e-05 2.866667 -5.0000000e-05 2.869444 -6.0000000e-05 2.872222 -7.0000000e-05 2.875000 -7.5000000e-05 2.877778 -8.0000000e-05 2.880556 -9.0000000e-05 2.883333 -1.0000000e-04 2.886111 -1.0000000e-04 2.888889 -1.0000000e-04 2.891667 -1.0000000e-04 2.894444 -9.0000000e-05 2.897222 -8.5000000e-05 2.900000 -8.5000000e-05 2.902778 -9.5000000e-05 2.905556 -1.0500000e-04 2.908333 -8.0000000e-05 2.911111 -6.5000000e-05 2.913889 -8.0000000e-05 2.916667 -9.5000000e-05 2.919444 -9.5000000e-05 2.922222 -9.0000000e-05 2.925000 -8.0000000e-05 2.927778 -8.0000000e-05 2.930556 -9.5000000e-05 2.933333 -9.0000000e-05 2.936111 -9.5000000e-05 2.938889 -9.0000000e-05 2.941667 -9.5000000e-05 2.944444 -8.0000000e-05 2.947222 -9.5000000e-05 2.950000 -1.0000000e-04 2.952778 -1.0000000e-04 2.955556 -9.5000000e-05 2.958333 -8.5000000e-05 2.961111 -7.0000000e-05 2.963889 -6.5000000e-05 2.966667 -8.0000000e-05 2.969444 -8.5000000e-05 2.972222 -9.5000000e-05 2.975000 -8.5000000e-05 2.977778 -9.0000000e-05 2.980556 -9.5000000e-05 2.983333 -1.0500000e-04 2.986111 -9.0000000e-05 2.988889 -8.0000000e-05 2.991667 -6.0000000e-05 2.994444 -4.5000000e-05 2.997222 -6.5000000e-05 3.000000 -7.0000000e-05 3.002778 -9.0000000e-05 3.005556 -9.0000000e-05 3.008333 -7.5000000e-05 3.011111 -7.0000000e-05 3.013889 -8.0000000e-05 3.016667 -8.5000000e-05 3.019444 -7.5000000e-05 3.022222 -7.5000000e-05 3.025000 -7.0000000e-05 3.027778 -7.0000000e-05 3.030556 -8.5000000e-05 3.033333 -9.0000000e-05 3.036111 -8.0000000e-05 3.038889 -8.0000000e-05 3.041667 -7.5000000e-05 3.044444 -8.5000000e-05 3.047222 -1.0500000e-04 3.050000 -1.1000000e-04 3.052778 -9.0000000e-05 3.055556 -9.0000000e-05 3.058333 -9.0000000e-05 3.061111 -8.5000000e-05 3.063889 -9.5000000e-05 3.066667 -9.5000000e-05 3.069444 -1.0000000e-04 3.072222 -1.1000000e-04 3.075000 -1.1000000e-04 3.077778 -8.5000000e-05 3.080556 -8.0000000e-05 3.083333 -8.0000000e-05 3.086111 -9.5000000e-05 3.088889 -9.0000000e-05 3.091667 -7.5000000e-05 3.094444 -7.5000000e-05 3.097222 -7.5000000e-05 3.100000 -9.0000000e-05 3.102778 -8.5000000e-05 3.105556 -9.5000000e-05 3.108333 -9.0000000e-05 3.111111 -9.0000000e-05 3.113889 -9.0000000e-05 3.116667 -1.1000000e-04 3.119444 -9.0000000e-05 3.122222 -9.0000000e-05 3.125000 -8.0000000e-05 3.127778 -8.0000000e-05 3.130556 -8.0000000e-05 3.133333 -9.0000000e-05 3.136111 -9.0000000e-05 3.138889 -9.5000000e-05 3.141667 -9.0000000e-05 3.144444 -8.0000000e-05 3.147222 -8.0000000e-05 3.150000 -9.0000000e-05 3.152778 -1.0000000e-04 3.155556 -1.1500000e-04 3.158333 -9.5000000e-05 3.161111 -8.5000000e-05 3.163889 -7.0000000e-05 3.166667 -7.0000000e-05 3.169444 -9.5000000e-05 3.172222 -1.0500000e-04 3.175000 -9.0000000e-05 3.177778 -6.5000000e-05 3.180556 -7.0000000e-05 3.183333 -7.5000000e-05 3.186111 -7.0000000e-05 3.188889 -7.5000000e-05 3.191667 -5.5000000e-05 3.194444 -5.0000000e-05 3.197222 -5.5000000e-05 3.200000 -4.5000000e-05 3.202778 -3.5000000e-05 3.205556 -4.0000000e-05 3.208333 -2.5000000e-05 3.211111 5.0000000e-06 3.213889 2.5000000e-05 3.216667 2.5000000e-05 3.219444 6.5000000e-05 3.222222 8.0000000e-05 3.225000 9.5000000e-05 3.227778 9.0000000e-05 3.230556 7.5000000e-05 3.233333 6.5000000e-05 3.236111 5.5000000e-05 3.238889 4.5000000e-05 3.241667 4.0000000e-05 3.244444 3.5000000e-05 3.247222 2.0000000e-05 3.250000 5.0000000e-06 3.252778 -1.0000000e-05 3.255556 -1.0000000e-05 3.258333 5.0000000e-06 3.261111 1.0000000e-05 3.263889 -2.0000000e-05 3.266667 -1.5000000e-05 3.269444 -3.5000000e-05 3.272222 -6.0000000e-05 3.275000 -6.5000000e-05 3.277778 -6.0000000e-05 3.280556 -6.5000000e-05 3.283333 -9.0000000e-05 3.286111 -1.0500000e-04 3.288889 -1.2000000e-04 3.291667 -1.1000000e-04 3.294444 -9.0000000e-05 3.297222 -8.5000000e-05 3.300000 -8.5000000e-05 3.302778 -1.0000000e-04 3.305556 -1.2000000e-04 3.308333 -1.1000000e-04 3.311111 -9.0000000e-05 3.313889 -1.0000000e-04 3.316667 -1.1000000e-04 3.319444 -1.1000000e-04 3.322222 -1.0500000e-04 3.325000 -9.0000000e-05 3.327778 -8.5000000e-05 3.330556 -1.0500000e-04 3.333333 -1.1500000e-04 3.336111 -1.0500000e-04 3.338889 -1.1000000e-04 3.341667 -1.1500000e-04 3.344444 -1.4500000e-04 3.347222 -1.6500000e-04 3.350000 -1.7500000e-04 3.352778 -1.3000000e-04 3.355556 1.0000000e-05 3.358333 2.4000000e-04 3.361111 5.2500000e-04 3.363889 8.3000000e-04 3.366667 1.1750000e-03 3.369444 1.4200000e-03 3.372222 1.4250000e-03 3.375000 1.1950000e-03 3.377778 8.9500000e-04 3.380556 5.7000000e-04 3.383333 2.9000000e-04 3.386111 1.4500000e-04 3.388889 7.5000000e-05 3.391667 2.5000000e-05 3.394444 -3.5000000e-05 3.397222 -7.0000000e-05 3.400000 -7.0000000e-05 3.402778 -8.0000000e-05 3.405556 -1.0000000e-04 3.408333 -1.1000000e-04 3.411111 -1.3500000e-04 3.413889 -1.5500000e-04 3.416667 -1.8500000e-04 3.419444 -2.0000000e-04 3.422222 -1.8500000e-04 3.425000 -1.8000000e-04 3.427778 -1.8500000e-04 3.430556 -1.9000000e-04 3.433333 -1.9500000e-04 3.436111 -2.1000000e-04 3.438889 -2.1000000e-04 3.441667 -2.0000000e-04 3.444444 -1.8000000e-04 3.447222 -1.9000000e-04 3.450000 -1.9000000e-04 3.452778 -2.1500000e-04 3.455556 -2.0500000e-04 3.458333 -2.0500000e-04 3.461111 -1.9000000e-04 3.463889 -1.9500000e-04 3.466667 -2.1000000e-04 3.469444 -2.1000000e-04 3.472222 -2.1000000e-04 3.475000 -1.9500000e-04 3.477778 -1.9000000e-04 3.480556 -1.8500000e-04 3.483333 -1.8000000e-04 3.486111 -1.9000000e-04 3.488889 -1.9500000e-04 3.491667 -1.8000000e-04 3.494444 -1.7000000e-04 3.497222 -1.6000000e-04 3.500000 -1.8000000e-04 3.502778 -1.8000000e-04 3.505556 -1.8500000e-04 3.508333 -1.7000000e-04 3.511111 -1.6000000e-04 3.513889 -1.6000000e-04 3.516667 -1.7500000e-04 3.519444 -1.7500000e-04 3.522222 -1.6500000e-04 3.525000 -1.6500000e-04 3.527778 -1.5000000e-04 3.530556 -1.5500000e-04 3.533333 -1.4500000e-04 3.536111 -1.5000000e-04 3.538889 -1.5000000e-04 3.541667 -1.4500000e-04 3.544444 -1.3000000e-04 3.547222 -1.3000000e-04 3.550000 -1.3000000e-04 3.552778 -1.4500000e-04 3.555556 -1.5000000e-04 3.558333 -1.3500000e-04 3.561111 -1.1000000e-04 3.563889 -1.0500000e-04 3.566667 -1.1000000e-04 3.569444 -1.0500000e-04 3.572222 -1.0500000e-04 3.575000 -1.0000000e-04 3.577778 -8.0000000e-05 3.580556 -7.0000000e-05 3.583333 -8.0000000e-05 3.586111 -7.5000000e-05 3.588889 -7.5000000e-05 3.591667 -6.0000000e-05 3.594444 -3.5000000e-05 3.597222 -2.0000000e-05 3.600000 -1.5000000e-05 3.602778 -1.5000000e-05 3.605556 -1.5000000e-05 3.608333 1.0000000e-05 3.611111 2.0000000e-05 3.613889 3.5000000e-05 3.616667 4.5000000e-05 3.619444 5.0000000e-05 3.622222 4.5000000e-05 3.625000 6.0000000e-05 3.627778 8.5000000e-05 3.630556 9.5000000e-05 3.633333 9.5000000e-05 3.636111 1.0000000e-04 3.638889 1.0000000e-04 3.641667 1.1500000e-04 3.644444 1.4000000e-04 3.647222 1.5500000e-04 3.650000 1.4000000e-04 3.652778 1.3000000e-04 3.655556 1.2000000e-04 3.658333 1.3000000e-04 3.661111 1.5000000e-04 3.663889 1.5000000e-04 3.666667 1.5000000e-04 3.669444 1.4000000e-04 3.672222 1.1500000e-04 3.675000 1.2000000e-04 3.677778 1.2000000e-04 3.680556 1.0500000e-04 3.683333 9.5000000e-05 3.686111 9.5000000e-05 3.688889 8.0000000e-05 3.691667 7.5000000e-05 3.694444 7.5000000e-05 3.697222 5.5000000e-05 3.700000 3.0000000e-05 3.702778 2.0000000e-05 3.705556 1.0000000e-05 3.708333 1.5000000e-05 3.711111 2.5000000e-05 3.713889 1.5000000e-05 3.716667 5.0000000e-06 3.719444 -1.5000000e-05 3.722222 -3.0000000e-05 3.725000 -2.0000000e-05 3.727778 -5.0000000e-06 3.730556 -2.5000000e-05 3.733333 -2.5000000e-05 3.736111 -4.5000000e-05 3.738889 -4.5000000e-05 3.741667 -3.0000000e-05 3.744444 -2.0000000e-05 3.747222 -2.5000000e-05 3.750000 -3.5000000e-05 3.752778 -4.5000000e-05 3.755556 -6.0000000e-05 3.758333 -4.0000000e-05 3.761111 -3.0000000e-05 3.763889 -3.5000000e-05 3.766667 -4.0000000e-05 3.769444 -3.0000000e-05 3.772222 -4.0000000e-05 3.775000 -3.5000000e-05 3.777778 -2.5000000e-05 3.780556 -2.0000000e-05 3.783333 -2.5000000e-05 3.786111 -2.5000000e-05 3.788889 -3.5000000e-05 3.791667 -5.0000000e-06 3.794444 -1.0000000e-05 3.797222 -1.0000000e-05 3.800000 -1.5000000e-05 3.802778 -1.5000000e-05 3.805556 -1.0000000e-05 3.808333 -1.5000000e-05 3.811111 0.0000000e+00 3.813889 -5.0000000e-06 3.816667 -5.0000000e-06 3.819444 -1.5000000e-05 3.822222 -5.0000000e-06 3.825000 1.5000000e-05 3.827778 1.0000000e-05 3.830556 5.0000000e-06 3.833333 1.0000000e-05 3.836111 1.0000000e-05 3.838889 -1.5000000e-05 3.841667 5.0000000e-06 3.844444 2.5000000e-05 3.847222 2.0000000e-05 3.850000 1.0000000e-05 3.852778 -5.0000000e-06 3.855556 -2.0000000e-05 3.858333 -5.0000000e-06 3.861111 2.0000000e-05 3.863889 1.5000000e-05 3.866667 0.0000000e+00 3.869444 0.0000000e+00 3.872222 0.0000000e+00 3.875000 -5.0000000e-06 3.877778 5.0000000e-06 3.880556 0.0000000e+00 3.883333 1.0000000e-05 3.886111 1.0000000e-05 3.888889 5.0000000e-06 3.891667 1.5000000e-05 3.894444 2.0000000e-05 3.897222 1.5000000e-05 3.900000 1.0000000e-05 3.902778 0.0000000e+00 3.905556 0.0000000e+00 3.908333 1.5000000e-05 3.911111 3.0000000e-05 3.913889 2.0000000e-05 3.916667 5.0000000e-06 3.919444 5.0000000e-06 3.922222 0.0000000e+00 3.925000 1.5000000e-05 3.927778 1.5000000e-05 3.930556 1.5000000e-05 3.933333 1.5000000e-05 3.936111 0.0000000e+00 3.938889 5.0000000e-06 3.941667 2.0000000e-05 3.944444 3.5000000e-05 3.947222 2.0000000e-05 3.950000 5.0000000e-06 3.952778 1.0000000e-05 3.955556 0.0000000e+00 3.958333 5.0000000e-06 3.961111 1.0000000e-05 3.963889 1.0000000e-05 3.966667 1.0000000e-05 3.969444 1.0000000e-05 3.972222 -5.0000000e-06 3.975000 2.0000000e-05 3.977778 3.0000000e-05 3.980556 2.5000000e-05 3.983333 1.0000000e-05 3.986111 1.5000000e-05 3.988889 5.0000000e-06 3.991667 5.0000000e-06 3.994444 2.5000000e-05 3.997222 2.0000000e-05 4.000000 2.0000000e-05 4.002778 1.0000000e-05 4.005556 1.5000000e-05 4.008333 1.5000000e-05 4.011111 2.5000000e-05 4.013889 2.0000000e-05 4.016667 2.5000000e-05 4.019444 1.5000000e-05 4.022222 5.0000000e-06 4.025000 2.5000000e-05 4.027778 4.0000000e-05 4.030556 3.5000000e-05 4.033333 2.5000000e-05 4.036111 2.0000000e-05 4.038889 3.0000000e-05 4.041667 4.0000000e-05 4.044444 6.0000000e-05 4.047222 5.0000000e-05 4.050000 4.5000000e-05 4.052778 4.5000000e-05 4.055556 5.0000000e-05 4.058333 6.0000000e-05 4.061111 7.5000000e-05 4.063889 7.0000000e-05 4.066667 7.5000000e-05 4.069444 9.5000000e-05 4.072222 1.1500000e-04 4.075000 1.5500000e-04 4.077778 1.9500000e-04 4.080556 2.1000000e-04 4.083333 2.1000000e-04 4.086111 1.9500000e-04 4.088889 1.9000000e-04 4.091667 1.8500000e-04 4.094444 1.9000000e-04 4.097222 1.8000000e-04 4.100000 1.5500000e-04 4.102778 1.4000000e-04 4.105556 1.4000000e-04 4.108333 1.4000000e-04 4.111111 1.4000000e-04 4.113889 1.6000000e-04 4.116667 1.5000000e-04 4.119444 1.2500000e-04 4.122222 1.1000000e-04 4.125000 1.1500000e-04 4.127778 1.0000000e-04 4.130556 7.0000000e-05 4.133333 6.0000000e-05 4.136111 6.0000000e-05 4.138889 4.0000000e-05 4.141667 4.5000000e-05 4.144444 5.5000000e-05 4.147222 5.0000000e-05 4.150000 3.5000000e-05 4.152778 1.5000000e-05 4.155556 1.0000000e-05 4.158333 1.5000000e-05 4.161111 3.0000000e-05 4.163889 3.0000000e-05 4.166667 2.5000000e-05 4.169444 1.0000000e-05 4.172222 1.0000000e-05 4.175000 1.0000000e-05 4.177778 2.0000000e-05 4.180556 2.5000000e-05 4.183333 1.0000000e-05 4.186111 5.0000000e-06 4.188889 1.5000000e-05 4.191667 1.5000000e-05 4.194444 -5.0000000e-06 4.197222 -4.5000000e-05 4.200000 -7.0000000e-05 4.202778 -7.5000000e-05 4.205556 -4.5000000e-05 4.208333 8.5000000e-05 4.211111 2.9000000e-04 4.213889 5.4000000e-04 4.216667 8.4500000e-04 4.219444 1.1700000e-03 4.222222 1.4650000e-03 4.225000 1.5850000e-03 4.227778 1.4200000e-03 4.230556 1.1250000e-03 4.233333 8.1500000e-04 4.236111 5.5500000e-04 4.238889 4.0500000e-04 4.241667 3.7500000e-04 4.244444 3.6500000e-04 4.247222 3.1500000e-04 4.250000 2.7000000e-04 4.252778 2.2000000e-04 4.255556 1.7500000e-04 4.258333 1.3000000e-04 4.261111 8.0000000e-05 4.263889 3.0000000e-05 4.266667 -1.5000000e-05 4.269444 -4.5000000e-05 4.272222 -4.5000000e-05 4.275000 -4.0000000e-05 4.277778 -3.5000000e-05 4.280556 -4.0000000e-05 4.283333 -5.0000000e-05 4.286111 -6.5000000e-05 4.288889 -8.5000000e-05 4.291667 -7.5000000e-05 4.294444 -6.5000000e-05 4.297222 -6.5000000e-05 4.300000 -8.0000000e-05 4.302778 -9.5000000e-05 4.305556 -8.5000000e-05 4.308333 -8.5000000e-05 4.311111 -7.5000000e-05 4.313889 -8.5000000e-05 4.316667 -8.0000000e-05 4.319444 -8.5000000e-05 4.322222 -9.5000000e-05 4.325000 -8.0000000e-05 4.327778 -7.5000000e-05 4.330556 -6.5000000e-05 4.333333 -7.5000000e-05 4.336111 -9.5000000e-05 4.338889 -7.0000000e-05 4.341667 -7.0000000e-05 4.344444 -7.0000000e-05 4.347222 -7.0000000e-05 4.350000 -7.5000000e-05 4.352778 -8.0000000e-05 4.355556 -7.5000000e-05 4.358333 -7.0000000e-05 4.361111 -5.0000000e-05 4.363889 -6.0000000e-05 4.366667 -7.0000000e-05 4.369444 -9.0000000e-05 4.372222 -9.0000000e-05 4.375000 -8.0000000e-05 4.377778 -6.5000000e-05 4.380556 -7.5000000e-05 4.383333 -9.0000000e-05 4.386111 -7.5000000e-05 4.388889 -6.0000000e-05 4.391667 -5.0000000e-05 4.394444 -5.0000000e-05 4.397222 -5.0000000e-05 4.400000 -5.5000000e-05 4.402778 -7.5000000e-05 4.405556 -7.0000000e-05 4.408333 -5.0000000e-05 4.411111 -4.0000000e-05 4.413889 -3.5000000e-05 4.416667 -4.0000000e-05 4.419444 -5.5000000e-05 4.422222 -5.0000000e-05 4.425000 -4.0000000e-05 4.427778 -1.5000000e-05 4.430556 -5.0000000e-06 4.433333 -1.0000000e-05 4.436111 -1.5000000e-05 4.438889 -5.0000000e-06 4.441667 1.5000000e-05 4.444444 3.0000000e-05 4.447222 3.5000000e-05 4.450000 3.5000000e-05 4.452778 5.0000000e-05 4.455556 6.5000000e-05 4.458333 7.0000000e-05 4.461111 9.0000000e-05 4.463889 1.1000000e-04 4.466667 1.0500000e-04 4.469444 1.1000000e-04 4.472222 1.2500000e-04 4.475000 1.4000000e-04 4.477778 1.6500000e-04 4.480556 1.6500000e-04 4.483333 1.5500000e-04 4.486111 1.4500000e-04 4.488889 1.5500000e-04 4.491667 1.7500000e-04 4.494444 2.1000000e-04 4.497222 2.0000000e-04 4.500000 2.0000000e-04 4.502778 2.0000000e-04 4.505556 1.9500000e-04 4.508333 2.2000000e-04 4.511111 2.3500000e-04 4.513889 2.3500000e-04 4.516667 2.2000000e-04 4.519444 2.0000000e-04 4.522222 2.0000000e-04 4.525000 2.2500000e-04 4.527778 2.3500000e-04 4.530556 2.2000000e-04 4.533333 1.9500000e-04 4.536111 1.7000000e-04 4.538889 1.6500000e-04 4.541667 1.7000000e-04 4.544444 1.4500000e-04 4.547222 1.4000000e-04 4.550000 1.2000000e-04 4.552778 9.5000000e-05 4.555556 8.0000000e-05 4.558333 9.5000000e-05 4.561111 9.5000000e-05 4.563889 6.0000000e-05 4.566667 4.5000000e-05 4.569444 4.0000000e-05 4.572222 3.5000000e-05 4.575000 4.5000000e-05 4.577778 5.0000000e-05 4.580556 3.5000000e-05 4.583333 2.5000000e-05 4.586111 0.0000000e+00 4.588889 5.0000000e-06 4.591667 1.5000000e-05 4.594444 2.0000000e-05 4.597222 1.5000000e-05 4.600000 5.0000000e-06 4.602778 5.0000000e-06 4.605556 -1.0000000e-05 4.608333 5.0000000e-06 4.611111 5.0000000e-06 4.613889 5.0000000e-06 4.616667 0.0000000e+00 4.619444 5.0000000e-06 4.622222 -5.0000000e-06 4.625000 3.0000000e-05 4.627778 2.0000000e-05 4.630556 1.5000000e-05 4.633333 1.0000000e-05 4.636111 0.0000000e+00 4.638889 0.0000000e+00 4.641667 5.0000000e-06 4.644444 5.0000000e-06 4.647222 5.0000000e-06 4.650000 0.0000000e+00 4.652778 -1.5000000e-05 4.655556 -5.0000000e-06 4.658333 1.5000000e-05 4.661111 3.0000000e-05 4.663889 2.0000000e-05 4.666667 0.0000000e+00 4.669444 5.0000000e-06 4.672222 5.0000000e-06 4.675000 1.0000000e-05 4.677778 2.5000000e-05 4.680556 3.0000000e-05 4.683333 1.0000000e-05 4.686111 1.5000000e-05 4.688889 1.5000000e-05 4.691667 2.0000000e-05 4.694444 2.5000000e-05 4.697222 2.0000000e-05 4.700000 2.0000000e-05 4.702778 1.0000000e-05 4.705556 1.0000000e-05 4.708333 2.0000000e-05 4.711111 1.5000000e-05 4.713889 1.0000000e-05 4.716667 0.0000000e+00 4.719444 0.0000000e+00 4.722222 5.0000000e-06 4.725000 5.0000000e-06 4.727778 2.0000000e-05 4.730556 2.5000000e-05 4.733333 2.5000000e-05 4.736111 0.0000000e+00 4.738889 5.0000000e-06 4.741667 1.0000000e-05 4.744444 2.0000000e-05 4.747222 2.5000000e-05 4.750000 5.0000000e-06 4.752778 -5.0000000e-06 4.755556 -2.0000000e-05 4.758333 1.0000000e-05 4.761111 2.5000000e-05 4.763889 2.0000000e-05 4.766667 1.0000000e-05 4.769444 0.0000000e+00 4.772222 0.0000000e+00 4.775000 1.5000000e-05 4.777778 2.5000000e-05 4.780556 2.0000000e-05 4.783333 2.0000000e-05 4.786111 1.5000000e-05 4.788889 5.0000000e-06 4.791667 5.0000000e-06 4.794444 5.0000000e-06 4.797222 2.0000000e-05 4.800000 1.5000000e-05 4.802778 -5.0000000e-06 4.805556 -1.0000000e-05 4.808333 5.0000000e-06 4.811111 1.0000000e-05 4.813889 1.5000000e-05 4.816667 5.0000000e-06 4.819444 0.0000000e+00 4.822222 0.0000000e+00 4.825000 1.5000000e-05 4.827778 2.5000000e-05 4.830556 2.0000000e-05 4.833333 1.5000000e-05 4.836111 5.0000000e-06 4.838889 0.0000000e+00 4.841667 1.5000000e-05 4.844444 5.0000000e-06 4.847222 2.0000000e-05 4.850000 5.0000000e-06 4.852778 -1.0000000e-05 4.855556 0.0000000e+00 4.858333 1.5000000e-05 4.861111 1.0000000e-05 4.863889 1.5000000e-05 4.866667 0.0000000e+00 4.869444 5.0000000e-06 4.872222 1.0000000e-05 4.875000 2.5000000e-05 4.877778 3.0000000e-05 4.880556 3.5000000e-05 4.883333 3.5000000e-05 4.886111 2.5000000e-05 4.888889 2.5000000e-05 4.891667 5.5000000e-05 4.894444 6.0000000e-05 4.897222 7.0000000e-05 4.900000 6.5000000e-05 4.902778 7.0000000e-05 4.905556 6.5000000e-05 4.908333 8.5000000e-05 4.911111 9.0000000e-05 4.913889 1.0500000e-04 4.916667 1.1500000e-04 4.919444 1.3000000e-04 4.922222 1.5500000e-04 4.925000 2.0500000e-04 4.927778 2.2000000e-04 4.930556 2.1500000e-04 4.933333 1.8000000e-04 4.936111 1.6500000e-04 4.938889 1.6000000e-04 4.941667 1.7000000e-04 4.944444 1.6000000e-04 4.947222 1.5000000e-04 4.950000 1.3500000e-04 4.952778 1.1500000e-04 4.955556 1.1000000e-04 4.958333 1.2000000e-04 4.961111 1.2500000e-04 4.963889 1.1000000e-04 4.966667 9.5000000e-05 4.969444 8.0000000e-05 4.972222 6.5000000e-05 4.975000 5.5000000e-05 4.977778 6.0000000e-05 4.980556 3.0000000e-05 4.983333 0.0000000e+00 4.986111 0.0000000e+00 4.988889 -1.0000000e-05 4.991667 5.0000000e-06 4.994444 0.0000000e+00 4.997222 -1.0000000e-05 5.000000 -2.0000000e-05 5.002778 -1.0000000e-05 5.005556 -1.5000000e-05 5.008333 -1.0000000e-05 5.011111 -3.0000000e-05 5.013889 -2.0000000e-05 5.016667 -3.0000000e-05 5.019444 -3.5000000e-05 5.022222 -3.5000000e-05 5.025000 -4.0000000e-05 5.027778 -3.0000000e-05 5.030556 -1.5000000e-05 5.033333 -3.0000000e-05 5.036111 -5.0000000e-05 5.038889 -6.0000000e-05 5.041667 -7.0000000e-05 5.044444 -7.5000000e-05 5.047222 -6.5000000e-05 5.050000 -4.0000000e-05 5.052778 4.5000000e-05 5.055556 2.2000000e-04 5.058333 4.3500000e-04 5.061111 6.6500000e-04 5.063889 9.5000000e-04 5.066667 1.2500000e-03 5.069444 1.3950000e-03 5.072222 1.3150000e-03 5.075000 1.0500000e-03 5.077778 7.7500000e-04 5.080556 5.0500000e-04 5.083333 3.3000000e-04 5.086111 2.7000000e-04 5.088889 2.6000000e-04 5.091667 2.3000000e-04 5.094444 1.9500000e-04 5.097222 1.5000000e-04 5.100000 1.1500000e-04 5.102778 7.5000000e-05 5.105556 1.0000000e-05 5.108333 -1.5000000e-05 5.111111 -5.0000000e-05 5.113889 -7.0000000e-05 5.116667 -7.5000000e-05 5.119444 -4.0000000e-05 5.122222 -2.0000000e-05 5.125000 -2.5000000e-05 5.127778 -6.5000000e-05 5.130556 -1.2500000e-04 5.133333 -1.7500000e-04 5.136111 -1.9000000e-04 5.138889 -1.7500000e-04 5.141667 -1.5000000e-04 5.144444 -1.5000000e-04 5.147222 -1.5500000e-04 5.150000 -1.5500000e-04 5.152778 -1.5500000e-04 5.155556 -1.6500000e-04 5.158333 -1.4500000e-04 5.161111 -1.4000000e-04 5.163889 -1.1500000e-04 5.166667 -1.3500000e-04 5.169444 -1.5500000e-04 5.172222 -1.6500000e-04 5.175000 -1.5500000e-04 5.177778 -1.4000000e-04 5.180556 -1.4500000e-04 5.183333 -1.5000000e-04 5.186111 -1.5000000e-04 5.188889 -1.5500000e-04 5.191667 -1.3500000e-04 5.194444 -1.4500000e-04 5.197222 -1.4000000e-04 5.200000 -1.3500000e-04 5.202778 -1.4000000e-04 5.205556 -1.5000000e-04 5.208333 -1.5500000e-04 5.211111 -1.4500000e-04 5.213889 -1.2000000e-04 5.216667 -1.3000000e-04 5.219444 -1.4000000e-04 5.222222 -1.6500000e-04 5.225000 -1.6500000e-04 5.227778 -1.4500000e-04 5.230556 -1.5000000e-04 5.233333 -1.4500000e-04 5.236111 -1.5500000e-04 5.238889 -1.4500000e-04 5.241667 -1.2500000e-04 5.244444 -1.3000000e-04 5.247222 -1.3000000e-04 5.250000 -1.2000000e-04 5.252778 -1.3500000e-04 5.255556 -1.3500000e-04 5.258333 -1.3000000e-04 5.261111 -1.2000000e-04 5.263889 -1.1000000e-04 5.266667 -1.2500000e-04 5.269444 -1.3000000e-04 5.272222 -1.2000000e-04 5.275000 -9.0000000e-05 5.277778 -9.5000000e-05 5.280556 -9.0000000e-05 5.283333 -1.0500000e-04 5.286111 -1.0500000e-04 5.288889 -9.5000000e-05 5.291667 -6.0000000e-05 5.294444 -6.5000000e-05 5.297222 -5.5000000e-05 5.300000 -5.5000000e-05 5.302778 -4.5000000e-05 5.305556 -4.0000000e-05 5.308333 -2.5000000e-05 5.311111 0.0000000e+00 5.313889 0.0000000e+00 5.316667 5.0000000e-06 5.319444 5.0000000e-06 5.322222 0.0000000e+00 5.325000 1.0000000e-05 5.327778 3.0000000e-05 5.330556 3.5000000e-05 5.333333 5.5000000e-05 5.336111 7.0000000e-05 5.338889 5.5000000e-05 5.341667 7.5000000e-05 5.344444 8.0000000e-05 5.347222 9.5000000e-05 5.350000 9.0000000e-05 5.352778 8.5000000e-05 5.355556 9.5000000e-05 5.358333 1.1500000e-04 5.361111 1.2000000e-04 5.363889 1.1000000e-04 5.366667 1.1000000e-04 5.369444 1.1500000e-04 5.372222 9.5000000e-05 5.375000 8.5000000e-05 5.377778 6.5000000e-05 5.380556 7.5000000e-05 5.383333 6.5000000e-05 5.386111 5.5000000e-05 5.388889 4.0000000e-05 5.391667 5.0000000e-05 5.394444 6.0000000e-05 5.397222 5.0000000e-05 5.400000 2.5000000e-05 5.402778 -1.0000000e-05 5.405556 -3.0000000e-05 5.408333 -2.5000000e-05 5.411111 -2.0000000e-05 5.413889 -2.0000000e-05 5.416667 -2.5000000e-05 5.419444 -3.5000000e-05 5.422222 -3.5000000e-05 5.425000 -3.0000000e-05 5.427778 -2.5000000e-05 5.430556 -1.0000000e-05 5.433333 -2.5000000e-05 5.436111 -4.5000000e-05 5.438889 -5.5000000e-05 5.441667 -5.5000000e-05 5.444444 -5.5000000e-05 5.447222 -4.0000000e-05 5.450000 -4.5000000e-05 5.452778 -7.0000000e-05 5.455556 -7.0000000e-05 5.458333 -5.5000000e-05 5.461111 -3.5000000e-05 5.463889 -4.5000000e-05 5.466667 -4.5000000e-05 5.469444 -4.0000000e-05 5.472222 -4.5000000e-05 5.475000 -3.5000000e-05 5.477778 -2.5000000e-05 5.480556 -3.0000000e-05 5.483333 -3.5000000e-05 5.486111 -3.5000000e-05 5.488889 -5.0000000e-05 5.491667 -3.0000000e-05 5.494444 -2.0000000e-05 5.497222 -1.0000000e-05 5.500000 -1.0000000e-05 5.502778 -2.0000000e-05 5.505556 -1.5000000e-05 5.508333 -1.5000000e-05 5.511111 -1.0000000e-05 5.513889 -1.0000000e-05 5.516667 -5.0000000e-06 5.519444 -1.5000000e-05 5.522222 -2.5000000e-05 5.525000 -1.0000000e-05 5.527778 5.0000000e-06 5.530556 2.5000000e-05 5.533333 1.0000000e-05 5.536111 5.0000000e-06 5.538889 -5.0000000e-06 5.541667 1.5000000e-05 5.544444 2.0000000e-05 5.547222 2.5000000e-05 5.550000 2.0000000e-05 5.552778 -1.0000000e-05 5.555556 -5.0000000e-06 5.558333 2.0000000e-05 5.561111 2.0000000e-05 5.563889 2.5000000e-05 5.566667 2.0000000e-05 5.569444 5.0000000e-06 5.572222 5.0000000e-06 5.575000 1.0000000e-05 5.577778 1.5000000e-05 5.580556 1.5000000e-05 5.583333 1.0000000e-05 5.586111 1.0000000e-05 5.588889 0.0000000e+00 5.591667 2.5000000e-05 5.594444 3.0000000e-05 5.597222 2.5000000e-05 5.600000 2.0000000e-05 5.602778 0.0000000e+00 5.605556 0.0000000e+00 5.608333 1.0000000e-05 5.611111 0.0000000e+00 5.613889 2.0000000e-05 5.616667 2.0000000e-05 5.619444 1.0000000e-05 5.622222 1.0000000e-05 5.625000 1.5000000e-05 5.627778 1.5000000e-05 5.630556 3.0000000e-05 5.633333 2.5000000e-05 5.636111 5.0000000e-06 5.638889 -2.0000000e-05 5.641667 -1.0000000e-05 5.644444 -5.0000000e-06 5.647222 1.5000000e-05 5.650000 2.5000000e-05 5.652778 5.0000000e-06 5.655556 0.0000000e+00 5.658333 1.0000000e-05 5.661111 1.5000000e-05 5.663889 1.5000000e-05 5.666667 1.0000000e-05 5.669444 5.0000000e-06 5.672222 0.0000000e+00 5.675000 -1.0000000e-05 5.677778 0.0000000e+00 5.680556 0.0000000e+00 5.683333 0.0000000e+00 5.686111 1.0000000e-05 5.688889 5.0000000e-06 5.691667 1.0000000e-05 5.694444 2.0000000e-05 5.697222 2.0000000e-05 5.700000 1.5000000e-05 5.702778 1.5000000e-05 5.705556 5.0000000e-06 5.708333 2.0000000e-05 5.711111 4.0000000e-05 5.713889 4.0000000e-05 5.716667 4.5000000e-05 5.719444 4.0000000e-05 5.722222 5.0000000e-05 5.725000 5.5000000e-05 5.727778 8.5000000e-05 5.730556 7.5000000e-05 5.733333 9.0000000e-05 5.736111 1.2000000e-04 5.738889 1.4500000e-04 5.741667 1.8500000e-04 5.744444 2.0000000e-04 5.747222 2.0000000e-04 5.750000 1.9000000e-04 5.752778 1.8000000e-04 5.755556 1.7500000e-04 5.758333 1.9000000e-04 5.761111 1.9000000e-04 5.763889 1.7000000e-04 5.766667 1.6000000e-04 5.769444 1.4000000e-04 5.772222 1.4500000e-04 5.775000 1.4000000e-04 5.777778 1.4500000e-04 5.780556 1.5000000e-04 5.783333 1.4500000e-04 5.786111 1.1500000e-04 5.788889 9.5000000e-05 5.791667 7.5000000e-05 5.794444 9.0000000e-05 5.797222 7.5000000e-05 5.800000 6.0000000e-05 5.802778 4.0000000e-05 5.805556 3.0000000e-05 5.808333 4.5000000e-05 5.811111 4.0000000e-05 5.813889 4.5000000e-05 5.816667 3.0000000e-05 5.819444 2.0000000e-05 5.822222 1.0000000e-05 5.825000 2.5000000e-05 5.827778 3.5000000e-05 5.830556 2.5000000e-05 5.833333 1.5000000e-05 5.836111 2.0000000e-05 5.838889 1.5000000e-05 5.841667 1.5000000e-05 5.844444 2.5000000e-05 5.847222 2.5000000e-05 5.850000 1.0000000e-05 5.852778 1.5000000e-05 5.855556 1.5000000e-05 5.858333 1.5000000e-05 5.861111 -1.0000000e-05 5.863889 -4.0000000e-05 5.866667 -6.5000000e-05 5.869444 -5.0000000e-05 5.872222 4.5000000e-05 5.875000 2.3500000e-04 5.877778 4.8500000e-04 5.880556 7.6000000e-04 5.883333 1.1050000e-03 5.886111 1.3900000e-03 5.888889 1.5200000e-03 5.891667 1.4000000e-03 5.894444 1.1200000e-03 5.897222 8.2000000e-04 5.900000 5.5500000e-04 5.902778 3.9500000e-04 5.905556 3.3500000e-04 5.908333 3.2000000e-04 5.911111 2.7500000e-04 5.913889 2.3000000e-04 5.916667 1.9500000e-04 5.919444 1.5500000e-04 5.922222 1.2500000e-04 5.925000 1.0000000e-04 5.927778 6.0000000e-05 5.930556 3.5000000e-05 5.933333 1.5000000e-05 5.936111 -1.0000000e-05 5.938889 -2.5000000e-05 5.941667 -1.5000000e-05 5.944444 -1.0000000e-05 5.947222 -2.0000000e-05 5.950000 -3.0000000e-05 5.952778 -2.5000000e-05 5.955556 -5.0000000e-05 5.958333 -5.0000000e-05 5.961111 -4.0000000e-05 5.963889 -3.0000000e-05 5.966667 -1.5000000e-05 5.969444 -3.0000000e-05 5.972222 -3.5000000e-05 5.975000 -3.0000000e-05 5.977778 -2.5000000e-05 5.980556 -3.0000000e-05 5.983333 -4.5000000e-05 5.986111 -5.5000000e-05 5.988889 -5.5000000e-05 5.991667 -3.5000000e-05 5.994444 -3.0000000e-05 5.997222 -3.0000000e-05 6.000000 -2.5000000e-05 6.002778 -3.0000000e-05 6.005556 -3.5000000e-05 6.008333 -2.5000000e-05 6.011111 -2.5000000e-05 6.013889 -1.0000000e-05 6.016667 -3.0000000e-05 6.019444 -2.0000000e-05 6.022222 -2.5000000e-05 6.025000 -2.0000000e-05 6.027778 -1.0000000e-05 6.030556 -1.5000000e-05 6.033333 -1.5000000e-05 6.036111 -2.5000000e-05 6.038889 -2.5000000e-05 6.041667 -5.0000000e-06 6.044444 -5.0000000e-06 6.047222 -1.0000000e-05 6.050000 -2.0000000e-05 6.052778 -2.0000000e-05 6.055556 -2.0000000e-05 6.058333 -2.0000000e-05 6.061111 5.0000000e-06 6.063889 5.0000000e-06 6.066667 0.0000000e+00 6.069444 -5.0000000e-06 6.072222 -2.0000000e-05 6.075000 1.5000000e-05 6.077778 3.5000000e-05 6.080556 3.5000000e-05 6.083333 2.5000000e-05 6.086111 3.0000000e-05 6.088889 2.5000000e-05 6.091667 3.5000000e-05 6.094444 5.0000000e-05 6.097222 3.5000000e-05 6.100000 5.0000000e-05 6.102778 4.5000000e-05 6.105556 4.0000000e-05 6.108333 7.0000000e-05 6.111111 8.0000000e-05 6.113889 8.5000000e-05 6.116667 8.5000000e-05 6.119444 9.0000000e-05 6.122222 9.0000000e-05 6.125000 1.0000000e-04 6.127778 1.2000000e-04 6.130556 1.3000000e-04 6.133333 1.3000000e-04 6.136111 1.3500000e-04 6.138889 1.3500000e-04 6.141667 1.6000000e-04 6.144444 1.8000000e-04 6.147222 1.9000000e-04 6.150000 2.0500000e-04 6.152778 2.0500000e-04 6.155556 2.0500000e-04 6.158333 2.2000000e-04 6.161111 2.3500000e-04 6.163889 2.4500000e-04 6.166667 2.4500000e-04 6.169444 2.3500000e-04 6.172222 2.3500000e-04 6.175000 2.6000000e-04 6.177778 2.7000000e-04 6.180556 2.8000000e-04 6.183333 2.9000000e-04 6.186111 2.8000000e-04 6.188889 2.7000000e-04 6.191667 2.9000000e-04 6.194444 2.9500000e-04 6.197222 2.8500000e-04 6.200000 2.8500000e-04 6.202778 2.7000000e-04 6.205556 2.6500000e-04 6.208333 2.7000000e-04 6.211111 2.5500000e-04 6.213889 2.4000000e-04 6.216667 2.3000000e-04 6.219444 2.0500000e-04 6.222222 1.8500000e-04 6.225000 1.7000000e-04 6.227778 1.8000000e-04 6.230556 1.7500000e-04 6.233333 1.6500000e-04 6.236111 1.5500000e-04 6.238889 1.4000000e-04 6.241667 1.4000000e-04 6.244444 1.3500000e-04 6.247222 1.1500000e-04 6.250000 1.1500000e-04 6.252778 1.0000000e-04 6.255556 9.0000000e-05 6.258333 1.0000000e-04 6.261111 1.1500000e-04 6.263889 1.0000000e-04 6.266667 9.0000000e-05 6.269444 9.0000000e-05 6.272222 7.5000000e-05 6.275000 8.5000000e-05 6.277778 8.5000000e-05 6.280556 9.0000000e-05 6.283333 9.0000000e-05 6.286111 8.0000000e-05 6.288889 8.5000000e-05 6.291667 9.5000000e-05 6.294444 1.0500000e-04 6.297222 1.1000000e-04 6.300000 9.0000000e-05 6.302778 8.0000000e-05 6.305556 8.0000000e-05 6.308333 8.5000000e-05 6.311111 9.5000000e-05 6.313889 1.0500000e-04 6.316667 1.1000000e-04 6.319444 8.5000000e-05 6.322222 7.5000000e-05 6.325000 9.0000000e-05 6.327778 9.5000000e-05 6.330556 9.5000000e-05 6.333333 1.0500000e-04 6.336111 1.0000000e-04 6.338889 1.0000000e-04 6.341667 1.0500000e-04 6.344444 1.1000000e-04 6.347222 1.1000000e-04 6.350000 1.1000000e-04 6.352778 9.0000000e-05 6.355556 9.0000000e-05 6.358333 1.0500000e-04 6.361111 1.1000000e-04 6.363889 1.3000000e-04 6.366667 1.1500000e-04 6.369444 1.2000000e-04 6.372222 1.0500000e-04 6.375000 1.2000000e-04 6.377778 1.2500000e-04 6.380556 1.3000000e-04 6.383333 1.3000000e-04 6.386111 1.1500000e-04 6.388889 1.0500000e-04 6.391667 1.0500000e-04 6.394444 1.2000000e-04 6.397222 1.2000000e-04 6.400000 1.2000000e-04 6.402778 9.5000000e-05 6.405556 9.5000000e-05 6.408333 1.0000000e-04 6.411111 1.2000000e-04 6.413889 1.2000000e-04 6.416667 1.2500000e-04 6.419444 1.0500000e-04 6.422222 1.0000000e-04 6.425000 1.0500000e-04 6.427778 1.1000000e-04 6.430556 1.1500000e-04 6.433333 1.1000000e-04 6.436111 8.5000000e-05 6.438889 9.0000000e-05 6.441667 1.1000000e-04 6.444444 1.2000000e-04 6.447222 1.1500000e-04 6.450000 1.1000000e-04 6.452778 1.0000000e-04 6.455556 9.0000000e-05 6.458333 9.0000000e-05 6.461111 1.0000000e-04 6.463889 1.1000000e-04 6.466667 1.0500000e-04 6.469444 1.1000000e-04 6.472222 9.0000000e-05 6.475000 8.5000000e-05 6.477778 1.0000000e-04 6.480556 1.0500000e-04 6.483333 1.0500000e-04 6.486111 9.0000000e-05 6.488889 9.0000000e-05 6.491667 1.0000000e-04 6.494444 1.0500000e-04 6.497222 9.5000000e-05 6.500000 7.5000000e-05 6.502778 7.0000000e-05 6.505556 7.5000000e-05 6.508333 1.1500000e-04 6.511111 1.2000000e-04 6.513889 9.5000000e-05 6.516667 8.0000000e-05 6.519444 7.5000000e-05 6.522222 7.5000000e-05 6.525000 8.0000000e-05 6.527778 1.0500000e-04 6.530556 1.0500000e-04 6.533333 9.5000000e-05 6.536111 9.5000000e-05 6.538889 8.0000000e-05 6.541667 8.0000000e-05 6.544444 9.0000000e-05 6.547222 9.5000000e-05 6.550000 9.0000000e-05 6.552778 9.0000000e-05 6.555556 8.5000000e-05 6.558333 8.5000000e-05 6.561111 9.5000000e-05 6.563889 1.1500000e-04 6.566667 1.2500000e-04 6.569444 1.4000000e-04 6.572222 1.4500000e-04 6.575000 1.4000000e-04 6.577778 1.4500000e-04 6.580556 1.4000000e-04 6.583333 1.3500000e-04 6.586111 1.4500000e-04 6.588889 1.6000000e-04 6.591667 2.0000000e-04 6.594444 2.3000000e-04 6.597222 2.5000000e-04 6.600000 2.7500000e-04 6.602778 2.6500000e-04 6.605556 2.5500000e-04 6.608333 2.4500000e-04 6.611111 2.3500000e-04 6.613889 2.5500000e-04 6.616667 2.6000000e-04 6.619444 2.3000000e-04 6.622222 2.0000000e-04 6.625000 2.0500000e-04 6.627778 2.1000000e-04 6.630556 2.2000000e-04 6.633333 2.2000000e-04 6.636111 2.1000000e-04 6.638889 1.9000000e-04 6.641667 1.6000000e-04 6.644444 1.7000000e-04 6.647222 1.4000000e-04 6.650000 1.2500000e-04 6.652778 1.0000000e-04 6.655556 8.0000000e-05 6.658333 7.5000000e-05 6.661111 8.5000000e-05 6.663889 9.5000000e-05 6.666667 1.0000000e-04 6.669444 7.5000000e-05 6.672222 6.5000000e-05 6.675000 8.0000000e-05 6.677778 1.0000000e-04 6.680556 1.1000000e-04 6.683333 1.1500000e-04 6.686111 1.0500000e-04 6.688889 9.5000000e-05 6.691667 1.0000000e-04 6.694444 1.0000000e-04 6.697222 8.0000000e-05 6.700000 7.5000000e-05 6.702778 7.0000000e-05 6.705556 7.0000000e-05 6.708333 8.0000000e-05 6.711111 6.5000000e-05 6.713889 4.0000000e-05 6.716667 0.0000000e+00 6.719444 -1.5000000e-05 6.722222 -2.5000000e-05 6.725000 2.5000000e-05 6.727778 1.7000000e-04 6.730556 3.7500000e-04 6.733333 6.2000000e-04 6.736111 8.9000000e-04 6.738889 1.1850000e-03 6.741667 1.4550000e-03 6.744444 1.5550000e-03 6.747222 1.4000000e-03 6.750000 1.1150000e-03 6.752778 8.3500000e-04 6.755556 5.7500000e-04 6.758333 3.8500000e-04 6.761111 3.2000000e-04 6.763889 3.2000000e-04 6.766667 2.9500000e-04 6.769444 2.6000000e-04 6.772222 2.2500000e-04 6.775000 2.0000000e-04 6.777778 1.7000000e-04 6.780556 1.3000000e-04 6.783333 7.5000000e-05 6.786111 3.0000000e-05 6.788889 2.5000000e-05 6.791667 3.0000000e-05 6.794444 5.5000000e-05 6.797222 5.0000000e-05 6.800000 2.0000000e-05 6.802778 -1.5000000e-05 6.805556 -2.0000000e-05 6.808333 -5.0000000e-06 6.811111 5.0000000e-06 6.813889 1.0000000e-05 6.816667 0.0000000e+00 6.819444 -2.5000000e-05 6.822222 -4.0000000e-05 6.825000 -3.0000000e-05 6.827778 -2.0000000e-05 6.830556 -3.0000000e-05 6.833333 -1.5000000e-05 6.836111 -2.0000000e-05 6.838889 -1.5000000e-05 6.841667 0.0000000e+00 6.844444 0.0000000e+00 6.847222 1.0000000e-05 6.850000 5.0000000e-06 6.852778 5.0000000e-06 6.855556 -1.0000000e-05 6.858333 -5.0000000e-06 6.861111 -5.0000000e-06 6.863889 -5.0000000e-06 6.866667 5.0000000e-06 6.869444 -5.0000000e-06 6.872222 0.0000000e+00 6.875000 1.5000000e-05 6.877778 2.0000000e-05 6.880556 1.5000000e-05 6.883333 5.0000000e-06 6.886111 5.0000000e-06 6.888889 1.0000000e-05 6.891667 1.5000000e-05 6.894444 2.0000000e-05 6.897222 2.5000000e-05 6.900000 3.5000000e-05 6.902778 3.0000000e-05 6.905556 3.5000000e-05 6.908333 3.5000000e-05 6.911111 4.5000000e-05 6.913889 3.5000000e-05 6.916667 3.5000000e-05 6.919444 3.5000000e-05 6.922222 3.0000000e-05 6.925000 5.5000000e-05 6.927778 6.0000000e-05 6.930556 6.5000000e-05 6.933333 6.5000000e-05 6.936111 7.0000000e-05 6.938889 8.0000000e-05 6.941667 9.5000000e-05 6.944444 9.0000000e-05 6.947222 9.5000000e-05 6.950000 9.5000000e-05 6.952778 1.0000000e-04 6.955556 9.5000000e-05 6.958333 1.1000000e-04 6.961111 1.1500000e-04 6.963889 9.5000000e-05 6.966667 9.5000000e-05 6.969444 1.2500000e-04 6.972222 1.2500000e-04 6.975000 1.5000000e-04 6.977778 1.5500000e-04 6.980556 1.6000000e-04 6.983333 1.9000000e-04 6.986111 1.8500000e-04 6.988889 1.8000000e-04 6.991667 2.0500000e-04 6.994444 2.2000000e-04 6.997222 2.4500000e-04 7.000000 2.4500000e-04 7.002778 2.5500000e-04 7.005556 2.5000000e-04 7.008333 2.6000000e-04 7.011111 2.7500000e-04 7.013889 2.9500000e-04 7.016667 2.9500000e-04 7.019444 2.9000000e-04 7.022222 2.8500000e-04 7.025000 3.1000000e-04 7.027778 3.1000000e-04 7.030556 3.2500000e-04 7.033333 3.1500000e-04 7.036111 3.3500000e-04 7.038889 3.4500000e-04 7.041667 3.6500000e-04 7.044444 3.7500000e-04 7.047222 3.7500000e-04 7.050000 3.5500000e-04 7.052778 3.3500000e-04 7.055556 3.1500000e-04 7.058333 3.2500000e-04 7.061111 3.3000000e-04 7.063889 3.4000000e-04 7.066667 3.4500000e-04 7.069444 3.3500000e-04 7.072222 3.3000000e-04 7.075000 3.1000000e-04 7.077778 2.8000000e-04 7.080556 2.6000000e-04 7.083333 2.4000000e-04 7.086111 2.2000000e-04 7.088889 2.1000000e-04 7.091667 2.0500000e-04 7.094444 2.3000000e-04 7.097222 2.3500000e-04 7.100000 2.3500000e-04 7.102778 2.1000000e-04 7.105556 1.8500000e-04 7.108333 1.8500000e-04 7.111111 1.8000000e-04 7.113889 1.8000000e-04 7.116667 1.7500000e-04 7.119444 1.6000000e-04 7.122222 1.4000000e-04 7.125000 1.2500000e-04 7.127778 1.4500000e-04 7.130556 1.6000000e-04 7.133333 1.5500000e-04 7.136111 1.4500000e-04 7.138889 1.2500000e-04 7.141667 1.2000000e-04 7.144444 1.2000000e-04 7.147222 1.2000000e-04 7.150000 1.1000000e-04 7.152778 1.2000000e-04 7.155556 1.1000000e-04 7.158333 1.4000000e-04 7.161111 1.4500000e-04 7.163889 1.4000000e-04 7.166667 1.3500000e-04 7.169444 1.3500000e-04 7.172222 1.2500000e-04 7.175000 1.3000000e-04 7.177778 1.3500000e-04 7.180556 1.3000000e-04 7.183333 1.3500000e-04 7.186111 1.2500000e-04 7.188889 1.2000000e-04 7.191667 1.4500000e-04 7.194444 1.5000000e-04 7.197222 1.6000000e-04 7.200000 1.4000000e-04 7.202778 1.4000000e-04 7.205556 1.1500000e-04 7.208333 1.3000000e-04 7.211111 1.2500000e-04 7.213889 1.3500000e-04 7.216667 1.4500000e-04 7.219444 1.6000000e-04 7.222222 1.4000000e-04 7.225000 1.3000000e-04 7.227778 1.3500000e-04 7.230556 1.4500000e-04 7.233333 1.7000000e-04 7.236111 1.8500000e-04 7.238889 1.6000000e-04 7.241667 1.4000000e-04 7.244444 1.4000000e-04 7.247222 1.6500000e-04 7.250000 1.6500000e-04 7.252778 1.6000000e-04 7.255556 1.4500000e-04 7.258333 1.4500000e-04 7.261111 1.4500000e-04 7.263889 1.4000000e-04 7.266667 1.4000000e-04 7.269444 1.4000000e-04 7.272222 1.4000000e-04 7.275000 1.6000000e-04 7.277778 1.6500000e-04 7.280556 1.7000000e-04 7.283333 1.7000000e-04 7.286111 1.5500000e-04 7.288889 1.3500000e-04 7.291667 1.2000000e-04 7.294444 1.2500000e-04 7.297222 1.4500000e-04 7.300000 1.7000000e-04 7.302778 1.7500000e-04 7.305556 1.5500000e-04 7.308333 1.5500000e-04 7.311111 1.6000000e-04 7.313889 1.7000000e-04 7.316667 1.7500000e-04 7.319444 1.6000000e-04 7.322222 1.5500000e-04 7.325000 1.5500000e-04 7.327778 1.7500000e-04 7.330556 1.7000000e-04 7.333333 1.5500000e-04 7.336111 1.4000000e-04 7.338889 1.2000000e-04 7.341667 1.4500000e-04 7.344444 1.7000000e-04 7.347222 1.7500000e-04 7.350000 1.6000000e-04 7.352778 1.4000000e-04 7.355556 1.2000000e-04 7.358333 1.2500000e-04 7.361111 1.5500000e-04 7.363889 1.7000000e-04 7.366667 1.7500000e-04 7.369444 1.6000000e-04 7.372222 1.5500000e-04 7.375000 1.3500000e-04 7.377778 1.4500000e-04 7.380556 1.3000000e-04 7.383333 1.4500000e-04 7.386111 1.4500000e-04 7.388889 1.4000000e-04 7.391667 1.6500000e-04 7.394444 1.7500000e-04 7.397222 1.7500000e-04 7.400000 1.7000000e-04 7.402778 1.6000000e-04 7.405556 1.3000000e-04 7.408333 1.4000000e-04 7.411111 1.6000000e-04 7.413889 1.6000000e-04 7.416667 1.5000000e-04 7.419444 1.4500000e-04 7.422222 1.3500000e-04 7.425000 1.5500000e-04 7.427778 1.6500000e-04 7.430556 1.4500000e-04 7.433333 1.4500000e-04 7.436111 1.5500000e-04 7.438889 1.6000000e-04 7.441667 1.5500000e-04 7.444444 1.5000000e-04 7.447222 1.7000000e-04 7.450000 1.9500000e-04 7.452778 1.9500000e-04 7.455556 1.8000000e-04 7.458333 1.9000000e-04 7.461111 1.9500000e-04 7.463889 2.1000000e-04 7.466667 2.1000000e-04 7.469444 2.0000000e-04 7.472222 1.8500000e-04 7.475000 1.9000000e-04 7.477778 2.3000000e-04 7.480556 2.4500000e-04 7.483333 2.6500000e-04 7.486111 2.9000000e-04 7.488889 3.0500000e-04 7.491667 3.3500000e-04 7.494444 3.3500000e-04 7.497222 3.2500000e-04 7.500000 3.1000000e-04 7.502778 3.1000000e-04 7.505556 2.8500000e-04 7.508333 2.8000000e-04 7.511111 2.6500000e-04 7.513889 2.7000000e-04 7.516667 2.6500000e-04 7.519444 2.6000000e-04 7.522222 2.6000000e-04 7.525000 2.8000000e-04 7.527778 3.0500000e-04 7.530556 2.8500000e-04 7.533333 2.5000000e-04 7.536111 2.1000000e-04 7.538889 1.8000000e-04 7.541667 1.6000000e-04 7.544444 1.4500000e-04 7.547222 1.3500000e-04 7.550000 1.1000000e-04 7.552778 1.0500000e-04 7.555556 1.1500000e-04 7.558333 1.2000000e-04 7.561111 1.5500000e-04 7.563889 1.7500000e-04 7.566667 1.6000000e-04 7.569444 1.6000000e-04 7.572222 1.3000000e-04 7.575000 1.3000000e-04 7.577778 1.2000000e-04 7.580556 1.1500000e-04 7.583333 8.5000000e-05 7.586111 5.0000000e-05 7.588889 2.5000000e-05 7.591667 2.0000000e-05 7.594444 4.0000000e-05 7.597222 7.5000000e-05 7.600000 8.0000000e-05 7.602778 8.5000000e-05 7.605556 7.5000000e-05 7.608333 8.0000000e-05 7.611111 9.0000000e-05 7.613889 7.5000000e-05 7.616667 4.0000000e-05 7.619444 5.0000000e-06 7.622222 -1.0000000e-05 7.625000 4.0000000e-05 7.627778 1.5000000e-04 7.630556 3.2000000e-04 7.633333 5.2500000e-04 7.636111 7.5500000e-04 7.638889 1.0250000e-03 7.641667 1.3300000e-03 7.644444 1.5300000e-03 7.647222 1.5400000e-03 7.650000 1.3400000e-03 7.652778 1.0700000e-03 7.655556 8.3500000e-04 7.658333 6.0500000e-04 7.661111 4.2500000e-04 7.663889 3.1500000e-04 7.666667 2.9000000e-04 7.669444 2.6000000e-04 7.672222 2.1000000e-04 7.675000 1.8500000e-04 7.677778 1.7500000e-04 7.680556 1.7000000e-04 7.683333 1.5000000e-04 7.686111 1.0500000e-04 7.688889 6.5000000e-05 7.691667 5.0000000e-05 7.694444 6.5000000e-05 7.697222 7.5000000e-05 7.700000 6.5000000e-05 7.702778 3.0000000e-05 7.705556 2.0000000e-05 7.708333 5.0000000e-06 7.711111 0.0000000e+00 7.713889 0.0000000e+00 7.716667 -1.0000000e-05 7.719444 -1.5000000e-05 7.722222 -2.0000000e-05 7.725000 -5.0000000e-06 7.727778 1.0000000e-05 7.730556 1.0000000e-05 7.733333 5.0000000e-06 7.736111 -1.0000000e-05 7.738889 -2.5000000e-05 7.741667 0.0000000e+00 7.744444 1.0000000e-05 7.747222 -1.0000000e-05 7.750000 -2.0000000e-05 7.752778 -2.5000000e-05 7.755556 -2.0000000e-05 7.758333 -2.0000000e-05 7.761111 -1.0000000e-05 7.763889 -5.0000000e-06 7.766667 0.0000000e+00 7.769444 -1.0000000e-05 7.772222 -1.0000000e-05 7.775000 -5.0000000e-06 7.777778 -1.5000000e-05 7.780556 -1.0000000e-05 7.783333 -5.0000000e-06 7.786111 0.0000000e+00 7.788889 5.0000000e-06 7.791667 5.0000000e-06 7.794444 1.5000000e-05 7.797222 2.0000000e-05 7.800000 2.5000000e-05 7.802778 1.5000000e-05 7.805556 -1.0000000e-05 7.808333 -5.0000000e-06 7.811111 -1.0000000e-05 7.813889 0.0000000e+00 7.816667 -1.0000000e-05 7.819444 1.5000000e-05 7.822222 1.5000000e-05 7.825000 5.0000000e-06 7.827778 -2.0000000e-05 7.830556 -2.5000000e-05 7.833333 -2.0000000e-05 7.836111 -5.0000000e-06 7.838889 1.0000000e-05 7.841667 4.0000000e-05 7.844444 5.0000000e-05 7.847222 6.5000000e-05 7.850000 4.5000000e-05 7.852778 4.0000000e-05 7.855556 3.0000000e-05 7.858333 3.0000000e-05 7.861111 4.0000000e-05 7.863889 8.0000000e-05 7.866667 9.5000000e-05 7.869444 9.0000000e-05 7.872222 6.0000000e-05 7.875000 4.0000000e-05 7.877778 6.0000000e-05 7.880556 8.5000000e-05 7.883333 1.0500000e-04 7.886111 1.0500000e-04 7.888889 1.0500000e-04 7.891667 1.3000000e-04 7.894444 1.4500000e-04 7.897222 1.4500000e-04 7.900000 1.3000000e-04 7.902778 1.2000000e-04 7.905556 1.2500000e-04 7.908333 1.4500000e-04 7.911111 1.6000000e-04 7.913889 1.7500000e-04 7.916667 1.8500000e-04 7.919444 1.7500000e-04 7.922222 1.7500000e-04 7.925000 1.9000000e-04 7.927778 2.1000000e-04 7.930556 2.4000000e-04 7.933333 2.3500000e-04 7.936111 2.3000000e-04 7.938889 2.3500000e-04 7.941667 2.4500000e-04 7.944444 2.6500000e-04 7.947222 2.6500000e-04 7.950000 2.7500000e-04 7.952778 2.7000000e-04 7.955556 2.4500000e-04 7.958333 2.6500000e-04 7.961111 2.8500000e-04 7.963889 2.8500000e-04 7.966667 2.8500000e-04 7.969444 2.7000000e-04 7.972222 2.7000000e-04 7.975000 2.8000000e-04 7.977778 2.9500000e-04 7.980556 2.9000000e-04 7.983333 3.0000000e-04 7.986111 2.7500000e-04 7.988889 2.4500000e-04 7.991667 2.2500000e-04 7.994444 2.3000000e-04 7.997222 2.4000000e-04 8.000000 2.4000000e-04 8.002778 2.2000000e-04 8.005556 1.9500000e-04 8.008333 1.8000000e-04 8.011111 1.5500000e-04 8.013889 1.3500000e-04 8.016667 1.4000000e-04 8.019444 1.4000000e-04 8.022222 1.2000000e-04 8.025000 1.1500000e-04 8.027778 1.1000000e-04 8.030556 1.1000000e-04 8.033333 1.2000000e-04 8.036111 9.5000000e-05 8.038889 7.5000000e-05 8.041667 7.5000000e-05 8.044444 8.0000000e-05 8.047222 9.5000000e-05 8.050000 1.0000000e-04 8.052778 8.0000000e-05 8.055556 7.0000000e-05 8.058333 8.5000000e-05 8.061111 9.5000000e-05 8.063889 1.0000000e-04 8.066667 9.0000000e-05 8.069444 8.0000000e-05 8.072222 8.0000000e-05 8.075000 9.5000000e-05 8.077778 9.5000000e-05 8.080556 9.0000000e-05 8.083333 6.5000000e-05 8.086111 6.5000000e-05 8.088889 7.0000000e-05 8.091667 8.5000000e-05 8.094444 7.5000000e-05 8.097222 7.5000000e-05 8.100000 6.5000000e-05 8.102778 6.0000000e-05 8.105556 6.5000000e-05 8.108333 7.5000000e-05 8.111111 8.5000000e-05 8.113889 8.0000000e-05 8.116667 8.5000000e-05 8.119444 8.5000000e-05 8.122222 7.0000000e-05 8.125000 5.5000000e-05 8.127778 6.0000000e-05 8.130556 7.5000000e-05 8.133333 8.5000000e-05 8.136111 1.1000000e-04 8.138889 1.1000000e-04 8.141667 1.1000000e-04 8.144444 1.2000000e-04 8.147222 1.1000000e-04 8.150000 9.0000000e-05 8.152778 1.0000000e-04 8.155556 9.0000000e-05 8.158333 1.0500000e-04 8.161111 1.1000000e-04 8.163889 1.1000000e-04 8.166667 1.0500000e-04 8.169444 1.0000000e-04 8.172222 7.0000000e-05 8.175000 8.5000000e-05 8.177778 1.0000000e-04 8.180556 1.3000000e-04 8.183333 1.1500000e-04 8.186111 1.0500000e-04 8.188889 9.5000000e-05 8.191667 9.0000000e-05 8.194444 8.5000000e-05 8.197222 8.5000000e-05 8.200000 1.0500000e-04 8.202778 9.5000000e-05 8.205556 8.0000000e-05 8.208333 7.0000000e-05 8.211111 7.5000000e-05 8.213889 7.5000000e-05 8.216667 9.0000000e-05 8.219444 1.1000000e-04 8.222222 9.0000000e-05 8.225000 7.5000000e-05 8.227778 5.5000000e-05 8.230556 5.5000000e-05 8.233333 6.5000000e-05 8.236111 9.5000000e-05 8.238889 8.5000000e-05 8.241667 9.5000000e-05 8.244444 9.0000000e-05 8.247222 9.5000000e-05 8.250000 1.1000000e-04 8.252778 1.1000000e-04 8.255556 9.5000000e-05 8.258333 8.5000000e-05 8.261111 9.5000000e-05 8.263889 1.1000000e-04 8.266667 1.2500000e-04 8.269444 1.3000000e-04 8.272222 9.5000000e-05 8.275000 8.5000000e-05 8.277778 8.5000000e-05 8.280556 9.5000000e-05 8.283333 9.0000000e-05 8.286111 8.0000000e-05 8.288889 7.0000000e-05 8.291667 7.5000000e-05 8.294444 9.0000000e-05 8.297222 1.0500000e-04 8.300000 9.0000000e-05 8.302778 7.0000000e-05 8.305556 7.5000000e-05 8.308333 8.5000000e-05 8.311111 1.0500000e-04 8.313889 1.0500000e-04 8.316667 1.0500000e-04 8.319444 9.0000000e-05 8.322222 7.5000000e-05 8.325000 9.0000000e-05 8.327778 8.0000000e-05 8.330556 7.5000000e-05 8.333333 7.5000000e-05 8.336111 7.5000000e-05 8.338889 6.5000000e-05 8.341667 8.0000000e-05 8.344444 8.0000000e-05 8.347222 8.0000000e-05 8.350000 8.0000000e-05 8.352778 9.5000000e-05 8.355556 9.5000000e-05 8.358333 9.5000000e-05 8.361111 1.0000000e-04 8.363889 1.1000000e-04 8.366667 1.2500000e-04 8.369444 1.2500000e-04 8.372222 1.2000000e-04 8.375000 1.3000000e-04 8.377778 1.5000000e-04 8.380556 1.5500000e-04 8.383333 1.7000000e-04 8.386111 1.7000000e-04 8.388889 1.3500000e-04 8.391667 1.1500000e-04 8.394444 1.2000000e-04 8.397222 1.5000000e-04 8.400000 2.0000000e-04 8.402778 2.2000000e-04 8.405556 2.6500000e-04 8.408333 2.9000000e-04 8.411111 2.7500000e-04 8.413889 2.4500000e-04 8.416667 2.5000000e-04 8.419444 2.6000000e-04 8.422222 2.5500000e-04 8.425000 2.3500000e-04 8.427778 2.2500000e-04 8.430556 2.2500000e-04 8.433333 2.2000000e-04 8.436111 2.0000000e-04 8.438889 1.8000000e-04 8.441667 1.8500000e-04 8.444444 1.8500000e-04 8.447222 1.9000000e-04 8.450000 1.9000000e-04 8.452778 1.7500000e-04 8.455556 1.4000000e-04 8.458333 1.2500000e-04 8.461111 1.1500000e-04 8.463889 1.0500000e-04 8.466667 9.0000000e-05 8.469444 9.0000000e-05 8.472222 8.0000000e-05 8.475000 9.5000000e-05 8.477778 1.0500000e-04 8.480556 1.0500000e-04 8.483333 1.3000000e-04 8.486111 1.4000000e-04 8.488889 1.4500000e-04 8.491667 1.1000000e-04 8.494444 6.5000000e-05 8.497222 3.0000000e-05 8.500000 1.0000000e-05 8.502778 1.5000000e-05 8.505556 3.0000000e-05 8.508333 3.5000000e-05 8.511111 3.5000000e-05 8.513889 4.5000000e-05 8.516667 4.5000000e-05 8.519444 3.0000000e-05 8.522222 2.5000000e-05 8.525000 2.0000000e-05 8.527778 2.5000000e-05 8.530556 3.0000000e-05 8.533333 2.0000000e-05 8.536111 3.5000000e-05 8.538889 7.0000000e-05 8.541667 1.6500000e-04 8.544444 3.3500000e-04 8.547222 5.2000000e-04 8.550000 7.6500000e-04 8.552778 1.0600000e-03 8.555556 1.2950000e-03 8.558333 1.3550000e-03 8.561111 1.1900000e-03 8.563889 9.1500000e-04 8.566667 6.6000000e-04 8.569444 4.4000000e-04 8.572222 2.8000000e-04 8.575000 2.1000000e-04 8.577778 1.9500000e-04 8.580556 1.6000000e-04 8.583333 1.3000000e-04 8.586111 1.3000000e-04 8.588889 1.1500000e-04 8.591667 1.2000000e-04 8.594444 1.0500000e-04 8.597222 8.5000000e-05 8.600000 3.5000000e-05 8.602778 1.5000000e-05 8.605556 -5.0000000e-06 8.608333 -1.5000000e-05 8.611111 -1.5000000e-05 8.613889 1.0000000e-05 8.616667 -5.0000000e-06 8.619444 0.0000000e+00 8.622222 -5.0000000e-06 8.625000 -2.5000000e-05 8.627778 -2.5000000e-05 8.630556 -3.0000000e-05 8.633333 -4.5000000e-05 8.636111 -4.5000000e-05 8.638889 -4.0000000e-05 8.641667 0.0000000e+00 8.644444 1.0000000e-05 8.647222 -1.5000000e-05 8.650000 -5.0000000e-05 8.652778 -5.5000000e-05 8.655556 -4.0000000e-05 8.658333 -2.0000000e-05 8.661111 -5.0000000e-06 8.663889 1.0000000e-05 8.666667 2.0000000e-05 8.669444 -5.0000000e-06 8.672222 -1.5000000e-05 8.675000 -3.0000000e-05 8.677778 -3.5000000e-05 8.680556 -3.0000000e-05 8.683333 -1.5000000e-05 8.686111 -1.0000000e-05 8.688889 1.5000000e-05 8.691667 1.5000000e-05 8.694444 0.0000000e+00 8.697222 1.0000000e-05 8.700000 1.5000000e-05 8.702778 0.0000000e+00 8.705556 -2.5000000e-05 8.708333 -1.0000000e-05 8.711111 2.0000000e-05 8.713889 3.5000000e-05 8.716667 4.0000000e-05 8.719444 4.0000000e-05 8.722222 1.0000000e-05 8.725000 5.0000000e-06 8.727778 -2.5000000e-05 8.730556 -2.0000000e-05 8.733333 0.0000000e+00 8.736111 5.0000000e-06 8.738889 1.5000000e-05 8.741667 5.0000000e-06 8.744444 5.0000000e-06 8.747222 1.5000000e-05 8.750000 1.5000000e-05 8.752778 1.5000000e-05 8.755556 5.0000000e-06 8.758333 1.5000000e-05 8.761111 2.0000000e-05 8.763889 4.5000000e-05 8.766667 5.0000000e-05 8.769444 6.0000000e-05 8.772222 5.5000000e-05 8.775000 5.5000000e-05 8.777778 6.0000000e-05 8.780556 6.0000000e-05 8.783333 7.0000000e-05 8.786111 8.5000000e-05 8.788889 7.5000000e-05 8.791667 6.0000000e-05 8.794444 9.0000000e-05 8.797222 1.2500000e-04 8.800000 1.4500000e-04 8.802778 1.5000000e-04 8.805556 1.4000000e-04 8.808333 1.5000000e-04 8.811111 1.6000000e-04 8.813889 1.7500000e-04 8.816667 1.7500000e-04 8.819444 1.9500000e-04 8.822222 2.0000000e-04 8.825000 2.1000000e-04 8.827778 2.2000000e-04 8.830556 2.2000000e-04 8.833333 2.3500000e-04 8.836111 2.3000000e-04 8.838889 2.2500000e-04 8.841667 2.3500000e-04 8.844444 2.5000000e-04 8.847222 2.8000000e-04 8.850000 2.8000000e-04 8.852778 2.7500000e-04 8.855556 2.7000000e-04 8.858333 2.6000000e-04 8.861111 2.6000000e-04 8.863889 2.8500000e-04 8.866667 3.0000000e-04 8.869444 3.0000000e-04 8.872222 2.8000000e-04 8.875000 2.7500000e-04 8.877778 2.6500000e-04 8.880556 2.6500000e-04 8.883333 2.6500000e-04 8.886111 2.7000000e-04 8.888889 2.6000000e-04 8.891667 2.5000000e-04 8.894444 2.3000000e-04 8.897222 2.1000000e-04 8.900000 1.9000000e-04 8.902778 1.7000000e-04 8.905556 1.5500000e-04 8.908333 1.5500000e-04 8.911111 1.6500000e-04 8.913889 1.8000000e-04 8.916667 1.7000000e-04 8.919444 1.4500000e-04 8.922222 1.3000000e-04 8.925000 1.4000000e-04 8.927778 1.5500000e-04 8.930556 1.5500000e-04 8.933333 1.3000000e-04 8.936111 1.2000000e-04 8.938889 8.5000000e-05 8.941667 7.5000000e-05 8.944444 8.5000000e-05 8.947222 8.0000000e-05 8.950000 8.5000000e-05 8.952778 7.5000000e-05 8.955556 6.0000000e-05 8.958333 5.5000000e-05 8.961111 7.5000000e-05 8.963889 9.0000000e-05 8.966667 1.0500000e-04 8.969444 1.1000000e-04 8.972222 8.0000000e-05 8.975000 9.5000000e-05 8.977778 8.0000000e-05 8.980556 7.5000000e-05 8.983333 6.5000000e-05 8.986111 5.0000000e-05 8.988889 5.0000000e-05 8.991667 4.5000000e-05 8.994444 7.0000000e-05 8.997222 1.0000000e-04 9.000000 1.2500000e-04 9.002778 1.1000000e-04 9.005556 8.0000000e-05 9.008333 6.0000000e-05 9.011111 8.5000000e-05 9.013889 1.0500000e-04 9.016667 1.0500000e-04 9.019444 8.0000000e-05 9.022222 7.0000000e-05 9.025000 6.5000000e-05 9.027778 8.0000000e-05 9.030556 9.5000000e-05 9.033333 1.0000000e-04 9.036111 1.1000000e-04 9.038889 1.1500000e-04 9.041667 1.3500000e-04 9.044444 1.3000000e-04 9.047222 1.3000000e-04 9.050000 1.4000000e-04 9.052778 1.6500000e-04 9.055556 1.6000000e-04 9.058333 1.3000000e-04 9.061111 9.5000000e-05 9.063889 7.5000000e-05 9.066667 6.0000000e-05 9.069444 8.0000000e-05 9.072222 1.0500000e-04 9.075000 1.1000000e-04 9.077778 1.0500000e-04 9.080556 6.0000000e-05 9.083333 1.0000000e-05 9.086111 5.0000000e-06 9.088889 1.5000000e-05 9.091667 4.5000000e-05 9.094444 6.0000000e-05 9.097222 6.5000000e-05 9.100000 6.5000000e-05 9.102778 6.0000000e-05 9.105556 4.5000000e-05 9.108333 4.5000000e-05 9.111111 5.0000000e-05 9.113889 7.0000000e-05 9.116667 5.0000000e-05 9.119444 5.0000000e-05 9.122222 4.0000000e-05 9.125000 5.0000000e-05 9.127778 6.0000000e-05 9.130556 4.5000000e-05 9.133333 5.5000000e-05 9.136111 4.5000000e-05 9.138889 5.0000000e-05 9.141667 6.5000000e-05 9.144444 7.0000000e-05 9.147222 6.0000000e-05 9.150000 4.0000000e-05 9.152778 4.5000000e-05 9.155556 4.5000000e-05 9.158333 5.5000000e-05 9.161111 6.0000000e-05 9.163889 6.5000000e-05 9.166667 5.5000000e-05 9.169444 4.0000000e-05 9.172222 5.0000000e-05 9.175000 7.5000000e-05 9.177778 7.5000000e-05 9.180556 8.5000000e-05 9.183333 6.0000000e-05 9.186111 3.5000000e-05 9.188889 4.0000000e-05 9.191667 5.0000000e-05 9.194444 7.5000000e-05 9.197222 7.5000000e-05 9.200000 6.5000000e-05 9.202778 6.5000000e-05 9.205556 6.5000000e-05 9.208333 5.0000000e-05 9.211111 4.0000000e-05 9.213889 5.5000000e-05 9.216667 6.5000000e-05 9.219444 8.0000000e-05 9.222222 9.5000000e-05 9.225000 1.2500000e-04 9.227778 1.2000000e-04 9.230556 1.2500000e-04 9.233333 1.2000000e-04 9.236111 1.2000000e-04 9.238889 1.2500000e-04 9.241667 1.1000000e-04 9.244444 9.5000000e-05 9.247222 7.0000000e-05 9.250000 7.5000000e-05 9.252778 8.5000000e-05 9.255556 8.0000000e-05 9.258333 1.1000000e-04 9.261111 1.3500000e-04 9.263889 1.8500000e-04 9.266667 2.2500000e-04 9.269444 2.4500000e-04 9.272222 2.4500000e-04 9.275000 2.3500000e-04 9.277778 2.1000000e-04 9.280556 1.7500000e-04 9.283333 1.5500000e-04 9.286111 1.6500000e-04 9.288889 1.8500000e-04 9.291667 1.8500000e-04 9.294444 1.9500000e-04 9.297222 1.9000000e-04 9.300000 1.9000000e-04 9.302778 1.8500000e-04 9.305556 1.6500000e-04 9.308333 1.7000000e-04 9.311111 1.3500000e-04 9.313889 1.0500000e-04 9.316667 8.5000000e-05 9.319444 8.0000000e-05 9.322222 6.5000000e-05 9.325000 6.0000000e-05 9.327778 6.5000000e-05 9.330556 8.0000000e-05 9.333333 8.5000000e-05 9.336111 7.0000000e-05 9.338889 5.5000000e-05 9.341667 3.5000000e-05 9.344444 3.5000000e-05 9.347222 4.5000000e-05 9.350000 4.0000000e-05 9.352778 1.5000000e-05 9.355556 -1.0000000e-05 9.358333 0.0000000e+00 9.361111 0.0000000e+00 9.363889 2.0000000e-05 9.366667 2.0000000e-05 9.369444 2.0000000e-05 9.372222 5.0000000e-06 9.375000 -1.0000000e-05 9.377778 -5.0000000e-06 9.380556 -1.0000000e-05 9.383333 -2.5000000e-05 9.386111 -4.5000000e-05 9.388889 -7.0000000e-05 9.391667 -8.5000000e-05 9.394444 -7.5000000e-05 9.397222 -1.5000000e-05 9.400000 1.3000000e-04 9.402778 3.4500000e-04 9.405556 5.7000000e-04 9.408333 8.8000000e-04 9.411111 1.2100000e-03 9.413889 1.4650000e-03 9.416667 1.4450000e-03 9.419444 1.1550000e-03 9.422222 8.1500000e-04 9.425000 5.2000000e-04 9.427778 3.4000000e-04 9.430556 2.6500000e-04 9.433333 2.3000000e-04 9.436111 1.4500000e-04 9.438889 8.5000000e-05 9.441667 5.5000000e-05 9.444444 4.5000000e-05 9.447222 3.0000000e-05 9.450000 3.0000000e-05 9.452778 0.0000000e+00 9.455556 -3.5000000e-05 9.458333 -5.0000000e-05 9.461111 -4.5000000e-05 9.463889 -4.0000000e-05 9.466667 -6.0000000e-05 9.469444 -7.5000000e-05 9.472222 -7.5000000e-05 9.475000 -7.0000000e-05 9.477778 -7.0000000e-05 9.480556 -7.5000000e-05 9.483333 -9.0000000e-05 9.486111 -9.0000000e-05 9.488889 -8.0000000e-05 9.491667 -6.0000000e-05 9.494444 -6.5000000e-05 9.497222 -7.0000000e-05 9.500000 -9.0000000e-05 9.502778 -1.0000000e-04 9.505556 -1.0000000e-04 9.508333 -8.5000000e-05 9.511111 -8.0000000e-05 9.513889 -5.5000000e-05 9.516667 -4.0000000e-05 9.519444 -3.0000000e-05 9.522222 -3.0000000e-05 9.525000 -5.5000000e-05 9.527778 -8.5000000e-05 9.530556 -1.0000000e-04 9.533333 -1.0500000e-04 9.536111 -1.0000000e-04 9.538889 -1.0500000e-04 9.541667 -7.5000000e-05 9.544444 -5.0000000e-05 9.547222 -4.5000000e-05 9.550000 -3.5000000e-05 9.552778 -4.0000000e-05 9.555556 -7.5000000e-05 9.558333 -9.5000000e-05 9.561111 -1.0500000e-04 9.563889 -1.1500000e-04 9.566667 -1.0000000e-04 9.569444 -1.0500000e-04 9.572222 -9.5000000e-05 9.575000 -8.0000000e-05 9.577778 -7.0000000e-05 9.580556 -6.5000000e-05 9.583333 -8.0000000e-05 9.586111 -9.5000000e-05 9.588889 -8.0000000e-05 9.591667 -9.0000000e-05 9.594444 -7.0000000e-05 9.597222 -8.5000000e-05 9.600000 -1.0000000e-04 9.602778 -1.0500000e-04 9.605556 -7.5000000e-05 9.608333 -5.5000000e-05 9.611111 -3.5000000e-05 9.613889 -1.5000000e-05 9.616667 -1.5000000e-05 9.619444 -4.0000000e-05 9.622222 -5.0000000e-05 9.625000 -3.5000000e-05 9.627778 -2.0000000e-05 9.630556 -2.5000000e-05 9.633333 -4.0000000e-05 9.636111 -5.0000000e-05 9.638889 -2.5000000e-05 9.641667 0.0000000e+00 9.644444 3.5000000e-05 9.647222 6.0000000e-05 9.650000 8.5000000e-05 9.652778 8.5000000e-05 9.655556 8.0000000e-05 9.658333 7.0000000e-05 9.661111 9.0000000e-05 9.663889 1.2000000e-04 9.666667 1.2000000e-04 9.669444 1.0000000e-04 9.672222 8.0000000e-05 9.675000 1.0000000e-04 9.677778 1.4500000e-04 9.680556 1.6500000e-04 9.683333 1.5500000e-04 9.686111 1.3000000e-04 9.688889 1.4000000e-04 9.691667 1.5500000e-04 9.694444 1.6500000e-04 9.697222 1.6000000e-04 9.700000 1.4500000e-04 9.702778 1.4500000e-04 9.705556 1.5000000e-04 9.708333 1.7500000e-04 9.711111 1.7000000e-04 9.713889 1.6000000e-04 9.716667 1.4000000e-04 9.719444 1.3500000e-04 9.722222 9.0000000e-05 9.725000 6.5000000e-05 9.727778 6.0000000e-05 9.730556 6.5000000e-05 9.733333 6.5000000e-05 9.736111 5.0000000e-05 9.738889 1.5000000e-05 9.741667 5.0000000e-06 9.744444 -5.0000000e-06 9.747222 0.0000000e+00 9.750000 -2.5000000e-05 9.752778 -5.0000000e-05 9.755556 -5.5000000e-05 9.758333 -5.5000000e-05 9.761111 -5.0000000e-05 9.763889 -4.0000000e-05 9.766667 -4.0000000e-05 9.769444 -3.5000000e-05 9.772222 -4.0000000e-05 9.775000 -5.0000000e-05 9.777778 -7.5000000e-05 9.780556 -8.5000000e-05 9.783333 -8.0000000e-05 9.786111 -9.0000000e-05 9.788889 -8.5000000e-05 9.791667 -7.0000000e-05 9.794444 -7.5000000e-05 9.797222 -5.5000000e-05 9.800000 -5.0000000e-05 9.802778 -7.0000000e-05 9.805556 -9.0000000e-05 9.808333 -7.5000000e-05 9.811111 -6.5000000e-05 9.813889 -6.0000000e-05 9.816667 -7.0000000e-05 9.819444 -8.5000000e-05 9.822222 -9.5000000e-05 9.825000 -8.0000000e-05 9.827778 -7.0000000e-05 9.830556 -4.5000000e-05 9.833333 -5.0000000e-05 9.836111 -7.0000000e-05 9.838889 -8.5000000e-05 9.841667 -9.0000000e-05 9.844444 -5.5000000e-05 9.847222 -4.0000000e-05 9.850000 -3.5000000e-05 9.852778 -4.5000000e-05 9.855556 -6.5000000e-05 9.858333 -5.0000000e-05 9.861111 -2.0000000e-05 9.863889 -2.5000000e-05 9.866667 -2.5000000e-05 9.869444 -4.0000000e-05 9.872222 -4.5000000e-05 9.875000 -5.5000000e-05 9.877778 -4.0000000e-05 9.880556 -5.0000000e-05 9.883333 -3.0000000e-05 9.886111 -3.5000000e-05 9.888889 -3.5000000e-05 9.891667 -3.5000000e-05 9.894444 -4.0000000e-05 9.897222 -5.0000000e-05 9.900000 -6.5000000e-05 9.902778 -7.0000000e-05 9.905556 -9.0000000e-05 9.908333 -8.5000000e-05 9.911111 -8.0000000e-05 9.913889 -6.5000000e-05 9.916667 -4.5000000e-05 9.919444 -6.0000000e-05 9.922222 -5.5000000e-05 9.925000 -2.5000000e-05 9.927778 1.0000000e-05 9.930556 5.0000000e-06 9.933333 -1.0000000e-05 9.936111 -4.5000000e-05 9.938889 -6.0000000e-05 9.941667 -8.0000000e-05 9.944444 -8.0000000e-05 9.947222 -6.0000000e-05 9.950000 -5.0000000e-05 9.952778 -4.0000000e-05 9.955556 -5.0000000e-05 9.958333 -5.0000000e-05 9.961111 -3.5000000e-05 9.963889 -3.0000000e-05 9.966667 -4.0000000e-05 9.969444 -5.0000000e-05 9.972222 -7.0000000e-05 9.975000 -9.5000000e-05 9.977778 -1.0500000e-04 9.980556 -8.0000000e-05 9.983333 -6.5000000e-05 9.986111 -6.0000000e-05 9.988889 -5.5000000e-05 9.991667 -7.0000000e-05 9.994444 -7.5000000e-05 9.997222 -6.5000000e-05 10.000000 -8.5000000e-05 10.002778 -1.1500000e-04 10.005556 -1.3000000e-04 10.008333 -1.1000000e-04 10.011111 -8.5000000e-05 10.013889 -8.0000000e-05 10.016667 -5.0000000e-05 10.019444 -3.5000000e-05 10.022222 -4.0000000e-05 10.025000 -4.5000000e-05 10.027778 -5.0000000e-05 10.030556 -6.0000000e-05 10.033333 -7.0000000e-05 10.036111 -8.0000000e-05 10.038889 -7.0000000e-05 10.041667 -6.5000000e-05 10.044444 -7.5000000e-05 10.047222 -7.5000000e-05 10.050000 -8.5000000e-05 10.052778 -9.5000000e-05 10.055556 -1.1000000e-04 10.058333 -8.5000000e-05 10.061111 -5.5000000e-05 10.063889 -3.0000000e-05 10.066667 -5.0000000e-05 10.069444 -9.0000000e-05 10.072222 -1.1000000e-04 10.075000 -9.0000000e-05 10.077778 -7.0000000e-05 10.080556 -5.5000000e-05 10.083333 -2.5000000e-05 10.086111 -5.0000000e-06 10.088889 -1.0000000e-05 10.091667 -2.5000000e-05 10.094444 -4.5000000e-05 10.097222 -4.0000000e-05 10.100000 -4.0000000e-05 10.102778 0.0000000e+00 10.105556 1.0000000e-05 10.108333 2.5000000e-05 10.111111 4.5000000e-05 10.113889 7.0000000e-05 10.116667 8.5000000e-05 10.119444 5.5000000e-05 10.122222 3.5000000e-05 10.125000 7.5000000e-05 10.127778 1.1500000e-04 10.130556 1.1000000e-04 10.133333 6.0000000e-05 10.136111 5.0000000e-06 10.138889 1.0000000e-05 10.141667 2.5000000e-05 10.144444 3.0000000e-05 10.147222 5.0000000e-06 10.150000 -1.0000000e-05 10.152778 -3.5000000e-05 10.155556 -3.5000000e-05 10.158333 -2.5000000e-05 10.161111 -4.5000000e-05 10.163889 -1.0500000e-04 10.166667 -1.4500000e-04 10.169444 -1.3500000e-04 10.172222 -1.0000000e-04 10.175000 -8.5000000e-05 10.177778 -1.0500000e-04 10.180556 -1.4500000e-04 10.183333 -1.8500000e-04 10.186111 -1.6500000e-04 10.188889 -1.3000000e-04 10.191667 -1.2500000e-04 10.194444 -1.3500000e-04 10.197222 -1.4000000e-04 10.200000 -1.5000000e-04 10.202778 -1.7000000e-04 10.205556 -1.9500000e-04 10.208333 -2.2000000e-04 10.211111 -2.3000000e-04 10.213889 -1.9000000e-04 10.216667 -1.4000000e-04 10.219444 -1.3000000e-04 10.222222 -1.6500000e-04 10.225000 -2.1500000e-04 10.227778 -2.3000000e-04 10.230556 -2.5000000e-04 10.233333 -2.5000000e-04 10.236111 -2.1000000e-04 10.238889 -7.5000000e-05 10.241667 1.7500000e-04 10.244444 4.7500000e-04 10.247222 8.3000000e-04 10.250000 1.2000000e-03 10.252778 1.4500000e-03 10.255556 1.4200000e-03 10.258333 1.1600000e-03 10.261111 8.1500000e-04 10.263889 4.6000000e-04 10.266667 1.8000000e-04 10.269444 3.5000000e-05 10.272222 -2.0000000e-05 10.275000 -6.5000000e-05 10.277778 -1.3000000e-04 10.280556 -1.5500000e-04 10.283333 -1.5500000e-04 10.286111 -1.3500000e-04 10.288889 -1.2000000e-04 10.291667 -1.3500000e-04 10.294444 -1.8500000e-04 10.297222 -2.3000000e-04 10.300000 -2.4500000e-04 10.302778 -2.5500000e-04 10.305556 -2.8500000e-04 10.308333 -2.9000000e-04 10.311111 -2.9000000e-04 10.313889 -2.5500000e-04 10.316667 -2.4000000e-04 10.319444 -2.6000000e-04 10.322222 -2.8000000e-04 10.325000 -2.8000000e-04 10.327778 -2.8500000e-04 10.330556 -2.6000000e-04 10.333333 -2.6500000e-04 10.336111 -2.7500000e-04 10.338889 -3.0500000e-04 10.341667 -3.1500000e-04 10.344444 -3.2000000e-04 10.347222 -3.1000000e-04 10.350000 -2.7000000e-04 10.352778 -2.4500000e-04 10.355556 -2.6000000e-04 10.358333 -2.8000000e-04 10.361111 -3.1000000e-04 10.363889 -3.1500000e-04 10.366667 -2.9000000e-04 10.369444 -2.7500000e-04 10.372222 -2.8500000e-04 10.375000 -2.7500000e-04 10.377778 -2.5500000e-04 10.380556 -2.6000000e-04 10.383333 -3.0500000e-04 10.386111 -3.4000000e-04 10.388889 -3.0500000e-04 10.391667 -2.6500000e-04 10.394444 -2.6500000e-04 10.397222 -2.6500000e-04 10.400000 -2.8000000e-04 10.402778 -2.8000000e-04 10.405556 -2.9000000e-04 10.408333 -2.5500000e-04 10.411111 -2.4500000e-04 10.413889 -2.6000000e-04 10.416667 -2.7000000e-04 10.419444 -2.8500000e-04 10.422222 -2.8000000e-04 10.425000 -2.7500000e-04 10.427778 -2.6500000e-04 10.430556 -2.7000000e-04 10.433333 -2.9500000e-04 10.436111 -2.9000000e-04 10.438889 -2.7000000e-04 10.441667 -2.5500000e-04 10.444444 -2.5000000e-04 10.447222 -2.4000000e-04 10.450000 -2.3000000e-04 10.452778 -2.1000000e-04 10.455556 -2.2500000e-04 10.458333 -2.4500000e-04 10.461111 -2.5500000e-04 10.463889 -2.4500000e-04 10.466667 -2.2500000e-04 10.469444 -1.8500000e-04 10.472222 -1.8500000e-04 10.475000 -1.9500000e-04 10.477778 -2.0000000e-04 10.480556 -1.9000000e-04 10.483333 -1.7500000e-04 10.486111 -1.5500000e-04 10.488889 -1.4500000e-04 10.491667 -1.0500000e-04 10.494444 -1.0000000e-04 10.497222 -1.2000000e-04 10.500000 -1.2000000e-04 10.502778 -8.5000000e-05 10.505556 -6.5000000e-05 10.508333 -6.5000000e-05 10.511111 -5.5000000e-05 10.513889 -3.5000000e-05 10.516667 -1.0000000e-05 10.519444 0.0000000e+00 10.522222 0.0000000e+00 10.525000 0.0000000e+00 10.527778 1.0000000e-05 10.530556 -1.0000000e-05 10.533333 -2.0000000e-05 10.536111 -1.0000000e-05 10.538889 5.0000000e-06 10.541667 5.0000000e-05 10.544444 7.0000000e-05 10.547222 6.5000000e-05 10.550000 2.5000000e-05 10.552778 0.0000000e+00 10.555556 -2.0000000e-05 10.558333 -1.5000000e-05 10.561111 -5.0000000e-06 10.563889 -2.0000000e-05 10.566667 -4.5000000e-05 10.569444 -8.5000000e-05 10.572222 -9.0000000e-05 10.575000 -7.5000000e-05 10.577778 -6.0000000e-05 10.580556 -6.5000000e-05 10.583333 -7.5000000e-05 10.586111 -8.5000000e-05 10.588889 -1.1000000e-04 10.591667 -1.0500000e-04 10.594444 -1.2500000e-04 10.597222 -1.5500000e-04 10.600000 -1.9500000e-04 10.602778 -2.1000000e-04 10.605556 -2.0500000e-04 10.608333 -2.0500000e-04 10.611111 -2.1500000e-04 10.613889 -1.7500000e-04 10.616667 -1.7000000e-04 10.619444 -1.8500000e-04 10.622222 -2.3000000e-04 10.625000 -2.7000000e-04 10.627778 -2.5500000e-04 10.630556 -2.2500000e-04 10.633333 -2.1000000e-04 10.636111 -1.9500000e-04 10.638889 -2.2500000e-04 10.641667 -2.4500000e-04 10.644444 -2.0000000e-04 10.647222 -1.8500000e-04 10.650000 -2.0000000e-04 10.652778 -2.3500000e-04 10.655556 -2.6500000e-04 10.658333 -2.5000000e-04 10.661111 -2.3000000e-04 10.663889 -2.1500000e-04 10.666667 -2.3500000e-04 10.669444 -2.6500000e-04 10.672222 -2.9500000e-04 10.675000 -2.7500000e-04 10.677778 -2.2000000e-04 10.680556 -1.8500000e-04 10.683333 -1.5000000e-04 10.686111 -1.8000000e-04 10.688889 -2.7000000e-04 10.691667 -2.9500000e-04 10.694444 -2.5500000e-04 10.697222 -2.0500000e-04 10.700000 -1.9500000e-04 10.702778 -2.1000000e-04 10.705556 -2.3000000e-04 10.708333 -2.2500000e-04 10.711111 -1.9500000e-04 10.713889 -2.0500000e-04 10.716667 -2.1000000e-04 10.719444 -2.1500000e-04 10.722222 -2.2500000e-04 10.725000 -2.1000000e-04 10.727778 -1.9000000e-04 10.730556 -1.6500000e-04 10.733333 -1.7000000e-04 10.736111 -1.6500000e-04 10.738889 -1.6500000e-04 10.741667 -1.8000000e-04 10.744444 -2.0000000e-04 10.747222 -2.1500000e-04 10.750000 -2.0500000e-04 10.752778 -2.0000000e-04 10.755556 -2.1500000e-04 10.758333 -2.0500000e-04 10.761111 -1.9500000e-04 10.763889 -2.1000000e-04 10.766667 -2.2500000e-04 10.769444 -2.3000000e-04 10.772222 -2.5000000e-04 10.775000 -2.2500000e-04 10.777778 -1.9500000e-04 10.780556 -1.9500000e-04 10.783333 -2.0000000e-04 10.786111 -2.2000000e-04 10.788889 -2.4500000e-04 10.791667 -2.0000000e-04 10.794444 -1.5500000e-04 10.797222 -1.4000000e-04 10.800000 -1.6500000e-04 10.802778 -2.2500000e-04 10.805556 -2.7000000e-04 10.808333 -2.6000000e-04 10.811111 -2.1500000e-04 10.813889 -1.9000000e-04 10.816667 -2.0000000e-04 10.819444 -2.1000000e-04 10.822222 -2.1500000e-04 10.825000 -2.0500000e-04 10.827778 -2.1000000e-04 10.830556 -2.1500000e-04 10.833333 -2.3000000e-04 10.836111 -2.4000000e-04 10.838889 -2.4500000e-04 10.841667 -2.1500000e-04 10.844444 -2.1500000e-04 10.847222 -2.1500000e-04 10.850000 -2.1000000e-04 10.852778 -1.9000000e-04 10.855556 -1.8500000e-04 10.858333 -1.7000000e-04 10.861111 -1.6500000e-04 10.863889 -2.0000000e-04 10.866667 -2.2000000e-04 10.869444 -2.1500000e-04 10.872222 -1.8000000e-04 10.875000 -1.5500000e-04 10.877778 -1.4500000e-04 10.880556 -1.7000000e-04 10.883333 -1.9500000e-04 10.886111 -2.1000000e-04 10.888889 -2.2000000e-04 10.891667 -2.3000000e-04 10.894444 -2.1500000e-04 10.897222 -1.7000000e-04 10.900000 -1.4000000e-04 10.902778 -1.2500000e-04 10.905556 -1.3000000e-04 10.908333 -1.3500000e-04 10.911111 -1.3000000e-04 10.913889 -1.2000000e-04 10.916667 -1.2500000e-04 10.919444 -1.0000000e-04 10.922222 -7.0000000e-05 10.925000 -4.5000000e-05 10.927778 0.0000000e+00 10.930556 5.5000000e-05 10.933333 6.0000000e-05 10.936111 1.5000000e-05 10.938889 -2.0000000e-05 10.941667 -2.0000000e-05 10.944444 -2.0000000e-05 10.947222 -1.0000000e-05 10.950000 -3.5000000e-05 10.952778 -5.0000000e-05 10.955556 -5.5000000e-05 10.958333 -7.5000000e-05 10.961111 -1.0000000e-04 10.963889 -9.0000000e-05 10.966667 -5.5000000e-05 10.969444 -3.5000000e-05 10.972222 -5.0000000e-05 10.975000 -1.0500000e-04 10.977778 -1.4000000e-04 10.980556 -1.8500000e-04 10.983333 -2.1500000e-04 10.986111 -1.8000000e-04 10.988889 -1.5500000e-04 10.991667 -1.5500000e-04 10.994444 -1.6500000e-04 10.997222 -1.7500000e-04 11.000000 -1.9500000e-04 11.002778 -1.9000000e-04 11.005556 -2.0000000e-04 11.008333 -2.1500000e-04 11.011111 -2.3500000e-04 11.013889 -2.2500000e-04 11.016667 -2.0000000e-04 11.019444 -1.9000000e-04 11.022222 -1.7000000e-04 11.025000 -1.8500000e-04 11.027778 -2.1500000e-04 11.030556 -2.3000000e-04 11.033333 -2.3000000e-04 11.036111 -2.3500000e-04 11.038889 -2.5000000e-04 11.041667 -2.8500000e-04 11.044444 -3.1000000e-04 11.047222 -2.8500000e-04 11.050000 -1.7500000e-04 11.052778 2.0000000e-05 11.055556 2.8000000e-04 11.058333 6.0500000e-04 11.061111 9.7000000e-04 11.063889 1.3400000e-03 11.066667 1.5700000e-03 11.069444 1.5650000e-03 11.072222 1.2850000e-03 11.075000 8.5000000e-04 11.077778 5.0500000e-04 11.080556 2.7500000e-04 11.083333 1.4500000e-04 11.086111 5.5000000e-05 11.088889 -5.0000000e-05 11.091667 -1.1500000e-04 11.094444 -1.1500000e-04 11.097222 -1.2500000e-04 11.100000 -1.6500000e-04 11.102778 -2.0500000e-04 11.105556 -2.2000000e-04 11.108333 -1.9500000e-04 11.111111 -1.8000000e-04 11.113889 -1.8000000e-04 11.116667 -1.9000000e-04 11.119444 -2.2000000e-04 11.122222 -2.5000000e-04 11.125000 -2.7000000e-04 11.127778 -2.7500000e-04 11.130556 -2.4000000e-04 11.133333 -2.3500000e-04 11.136111 -2.4000000e-04 11.138889 -2.5000000e-04 11.141667 -2.4000000e-04 11.144444 -2.3000000e-04 11.147222 -2.2500000e-04 11.150000 -2.4500000e-04 11.152778 -2.7500000e-04 11.155556 -2.9000000e-04 11.158333 -2.8000000e-04 11.161111 -2.5000000e-04 11.163889 -2.2500000e-04 11.166667 -2.2500000e-04 11.169444 -2.2500000e-04 11.172222 -2.2000000e-04 11.175000 -2.0000000e-04 11.177778 -1.9000000e-04 11.180556 -1.8500000e-04 11.183333 -1.8000000e-04 11.186111 -2.0000000e-04 11.188889 -2.2000000e-04 11.191667 -2.3000000e-04 11.194444 -2.3500000e-04 11.197222 -2.1500000e-04 11.200000 -2.0000000e-04 11.202778 -2.0000000e-04 11.205556 -2.1500000e-04 11.208333 -2.1500000e-04 11.211111 -1.9500000e-04 11.213889 -2.1500000e-04 11.216667 -2.3000000e-04 11.219444 -2.5500000e-04 11.222222 -2.9500000e-04 11.225000 -2.5000000e-04 11.227778 -1.6500000e-04 11.230556 -1.4000000e-04 11.233333 -1.6000000e-04 11.236111 -1.8500000e-04 11.238889 -2.0500000e-04 11.241667 -1.9000000e-04 11.244444 -1.9000000e-04 11.247222 -2.0000000e-04 11.250000 -1.7000000e-04 11.252778 -1.4500000e-04 11.255556 -1.9500000e-04 11.258333 -2.2500000e-04 11.261111 -1.6500000e-04 11.263889 -3.5000000e-05 11.266667 1.5000000e-05 11.269444 -8.0000000e-05 11.272222 -1.6500000e-04 11.275000 -1.3000000e-04 11.277778 -2.0000000e-05 11.280556 2.5000000e-05 11.283333 -2.5000000e-05 11.286111 -6.0000000e-05 11.288889 -1.1000000e-04 11.291667 -1.3500000e-04 11.294444 -8.0000000e-05 11.297222 -2.5000000e-05 11.300000 -1.0000000e-05 11.302778 1.5000000e-05 11.305556 1.0000000e-05 11.308333 -2.0000000e-05 11.311111 -4.5000000e-05 11.313889 -2.5000000e-05 11.316667 2.0000000e-05 11.319444 5.0000000e-05 11.322222 1.0500000e-04 11.325000 1.7000000e-04 11.327778 1.7000000e-04 11.330556 1.0500000e-04 11.333333 6.0000000e-05 11.336111 8.0000000e-05 11.338889 1.6500000e-04 11.341667 2.0500000e-04 11.344444 2.2000000e-04 11.347222 2.3000000e-04 11.350000 2.0500000e-04 11.352778 1.6500000e-04 11.355556 1.0500000e-04 11.358333 4.5000000e-05 11.361111 7.5000000e-05 11.363889 1.9500000e-04 11.366667 2.5500000e-04 11.369444 2.1500000e-04 11.372222 1.6500000e-04 11.375000 1.7000000e-04 11.377778 1.9000000e-04 11.380556 1.4500000e-04 11.383333 5.0000000e-05 11.386111 -2.5000000e-05 11.388889 -2.0000000e-05 11.391667 2.0000000e-05 11.394444 5.0000000e-06 11.397222 0.0000000e+00 11.400000 -2.0000000e-05 11.402778 -6.5000000e-05 11.405556 -1.4500000e-04 11.408333 -1.2000000e-04 11.411111 1.0000000e-05 11.413889 1.2000000e-04 11.416667 1.0500000e-04 11.419444 -2.5000000e-05 11.422222 -1.2500000e-04 11.425000 -1.3000000e-04 11.427778 -7.0000000e-05 11.430556 -3.0000000e-05 11.433333 -2.5000000e-05 11.436111 -4.0000000e-05 11.438889 -5.0000000e-05 11.441667 -6.5000000e-05 11.444444 -1.0500000e-04 11.447222 -1.3000000e-04 11.450000 -1.5000000e-04 11.452778 -1.6500000e-04 11.455556 -2.2500000e-04 11.458333 -2.3000000e-04 11.461111 -1.2000000e-04 11.463889 5.5000000e-05 11.466667 9.0000000e-05 11.469444 0.0000000e+00 11.472222 -3.0000000e-05 11.475000 -5.0000000e-05 11.477778 -1.0000000e-04 11.480556 -1.1500000e-04 11.483333 -1.0000000e-04 11.486111 -1.0000000e-04 11.488889 -1.3000000e-04 11.491667 -1.7500000e-04 11.494444 -1.5000000e-04 11.497222 -9.0000000e-05 11.500000 -5.0000000e-05 11.502778 -7.5000000e-05 11.505556 -8.0000000e-05 11.508333 -3.0000000e-05 11.511111 2.5000000e-05 11.513889 5.0000000e-05 11.516667 1.0000000e-05 11.519444 -6.5000000e-05 11.522222 -1.1000000e-04 11.525000 -1.2000000e-04 11.527778 -1.1500000e-04 11.530556 -8.0000000e-05 11.533333 -4.0000000e-05 11.536111 -1.5000000e-05 11.538889 -3.0000000e-05 11.541667 -7.5000000e-05 11.544444 -1.1000000e-04 11.547222 -1.0000000e-04 11.550000 -4.0000000e-05 11.552778 -1.5000000e-05 11.555556 -3.0000000e-05 11.558333 -9.0000000e-05 11.561111 -1.5500000e-04 11.563889 -1.4000000e-04 11.566667 -6.5000000e-05 11.569444 5.0000000e-06 11.572222 0.0000000e+00 11.575000 -4.5000000e-05 11.577778 -8.0000000e-05 11.580556 -8.5000000e-05 11.583333 -7.0000000e-05 11.586111 -4.0000000e-05 11.588889 -1.0000000e-05 11.591667 -2.5000000e-05 11.594444 -9.5000000e-05 11.597222 -7.5000000e-05 11.600000 2.0000000e-05 11.602778 3.5000000e-05 11.605556 -5.0000000e-05 11.608333 -1.2500000e-04 11.611111 -1.4000000e-04 11.613889 -4.0000000e-05 11.616667 2.0000000e-05 11.619444 5.0000000e-06 11.622222 -1.0500000e-04 11.625000 -2.1500000e-04 11.627778 -1.7500000e-04 11.630556 1.0000000e-05 11.633333 1.7500000e-04 11.636111 1.4500000e-04 11.638889 -5.0000000e-06 11.641667 -1.3500000e-04 11.644444 -1.9500000e-04 11.647222 -1.2500000e-04 11.650000 1.5000000e-05 11.652778 1.1500000e-04 11.655556 7.0000000e-05 11.658333 -2.0000000e-05 11.661111 -5.5000000e-05 11.663889 -1.0500000e-04 11.666667 -1.7000000e-04 11.669444 -1.8500000e-04 11.672222 -6.5000000e-05 11.675000 9.0000000e-05 11.677778 1.5500000e-04 11.680556 1.0500000e-04 11.683333 2.5000000e-05 11.686111 -6.0000000e-05 11.688889 -1.1500000e-04 11.691667 -1.0000000e-04 11.694444 -8.0000000e-05 11.697222 -8.0000000e-05 11.700000 -6.5000000e-05 11.702778 -5.0000000e-06 11.705556 5.5000000e-05 11.708333 1.0000000e-04 11.711111 1.3500000e-04 11.713889 1.9500000e-04 11.716667 2.2500000e-04 11.719444 1.9000000e-04 11.722222 8.0000000e-05 11.725000 -1.5000000e-05 11.727778 5.0000000e-06 11.730556 1.0000000e-04 11.733333 1.8000000e-04 11.736111 2.0000000e-04 11.738889 1.6000000e-04 11.741667 9.0000000e-05 11.744444 4.0000000e-05 11.747222 1.0000000e-05 11.750000 5.0000000e-06 11.752778 5.0000000e-06 11.755556 -2.5000000e-05 11.758333 -7.5000000e-05 11.761111 -7.0000000e-05 11.763889 5.0000000e-06 11.766667 6.0000000e-05 11.769444 3.0000000e-05 11.772222 -5.0000000e-05 11.775000 -1.0000000e-04 11.777778 -9.5000000e-05 11.780556 -1.2500000e-04 11.783333 -1.6000000e-04 11.786111 -1.0000000e-04 11.788889 3.5000000e-05 11.791667 7.5000000e-05 11.794444 1.0000000e-05 11.797222 -8.0000000e-05 11.800000 -1.1500000e-04 11.802778 -9.0000000e-05 11.805556 -7.0000000e-05 11.808333 -4.5000000e-05 11.811111 -3.0000000e-05 11.813889 -5.5000000e-05 11.816667 -9.0000000e-05 11.819444 -9.5000000e-05 11.822222 -7.0000000e-05 11.825000 -4.5000000e-05 11.827778 -5.5000000e-05 11.830556 -1.3000000e-04 11.833333 -2.1500000e-04 11.836111 -2.4500000e-04 11.838889 -2.3500000e-04 11.841667 -1.7000000e-04 11.844444 5.0000000e-06 11.847222 2.5500000e-04 11.850000 5.7000000e-04 11.852778 9.4500000e-04 11.855556 1.3650000e-03 11.858333 1.6950000e-03 11.861111 1.7750000e-03 11.863889 1.5500000e-03 11.866667 1.1450000e-03 11.869444 7.5000000e-04 11.872222 4.3500000e-04 11.875000 3.3000000e-04 11.877778 3.3500000e-04 11.880556 2.2500000e-04 11.883333 -2.5000000e-05 11.886111 -1.3500000e-04 11.888889 -5.0000000e-06 11.891667 1.3000000e-04 11.894444 1.1000000e-04 11.897222 1.0000000e-05 11.900000 -7.0000000e-05 11.902778 -1.1500000e-04 11.905556 -1.6000000e-04 11.908333 -2.1500000e-04 11.911111 -1.9500000e-04 11.913889 -1.3000000e-04 11.916667 -1.1000000e-04 11.919444 -1.5000000e-04 11.922222 -1.8500000e-04 11.925000 -1.4000000e-04 11.927778 -6.0000000e-05 11.930556 -2.0000000e-05 11.933333 -3.0000000e-05 11.936111 -1.0500000e-04 11.938889 -1.7500000e-04 11.941667 -2.0500000e-04 11.944444 -1.1500000e-04 11.947222 -5.0000000e-05 11.950000 -5.5000000e-05 11.952778 -1.2500000e-04 11.955556 -1.8500000e-04 11.958333 -2.1000000e-04 11.961111 -1.8000000e-04 11.963889 -1.7500000e-04 11.966667 -2.5500000e-04 11.969444 -2.8000000e-04 11.972222 -2.3500000e-04 11.975000 -1.1000000e-04 11.977778 -4.5000000e-05 11.980556 -5.0000000e-05 11.983333 -1.3500000e-04 11.986111 -1.9000000e-04 11.988889 -1.9000000e-04 11.991667 -1.8500000e-04 11.994444 -1.4500000e-04 11.997222 -1.2000000e-04)
BINP inp 0 V = 1.5 + 0.5*V(ecg) + 0.05
BINN inn 0 V = 1.5 - 0.5*V(ecg) - 0.05
* INA333: G = 1 + 100k/RG, output = REFpin + G*(in+ - in-), bandwidth ~ 150 kHz/G (datasheet GBW)
BINA ina_o 0 V = max(min(V(srv) + 10.0090*(V(inp)-V(inn)), 2.95), 0.05)
* DC servo: integrator drives the in-amp REF pin -> first-order high-pass at 1/(2*pi*Rs*Cs)
Rs ina_o s_in 10MEG
Cs s_in srv 330n
XS ref s_in srv vcc 0 OPA gbw=8k
* gain stage x30 (non-inverting about VREF)
Rg1 g_inv ref 10k
Rf1 g_inv g_out 290k
XG ina_o g_inv g_out vcc 0 OPA gbw=8k
* unity-gain Sallen-Key Butterworth LPF, fc = 40 Hz (R = 100k, C1 = 56n, C2 = 27n)
R1 g_out sk1 100k
R2 sk1 sk2 100k
C1 sk1 out 56n
C2 sk2 ref 27n
XL sk2 out out vcc 0 OPA gbw=8k
.options method=gear reltol=1e-4
* servo pre-charged to its steady state (what a fast-restore switch achieves at power-up)
.ic v(srv)=0.4991 v(s_in)=1.5
.control
tran 0.5m 11.997 0 0.5m uic
wrdata /home/claude/isoline/hardware/sim/afe_out.txt v(out) v(ina_o) v(srv)
quit
.endc
.end
